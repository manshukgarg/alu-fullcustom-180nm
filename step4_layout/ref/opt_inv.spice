* LVS reference for opt_inv: inv_cmos at k = 0.8, r = 2.5 (devices as laid out)
.subckt opt_inv A Y vdd gnd
M0 gnd A Y gnd nfet w=0.8u l=0.2u
M1 vdd A Y vdd pfet w=2u l=0.2u
.ends opt_inv
