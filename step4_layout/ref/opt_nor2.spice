* LVS reference for opt_nor2: nor2_cmos at k = 0.6, r = 2.5 (devices as laid out)
.subckt opt_nor2 A B Y vdd gnd
M0 gnd A Y gnd nfet w=0.6u l=0.2u
M1 Y A x vdd pfet w=3u l=0.2u
M2 Y B gnd gnd nfet w=0.6u l=0.2u
M3 x B vdd vdd pfet w=3u l=0.2u
.ends opt_nor2
