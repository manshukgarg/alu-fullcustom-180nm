* tb_pl_fb4.cir  test of cell pl_fb4 (FB4, 20 transistors)
* Function: P = C0, C1, C2, C3 for (A, B) = 00, 01, 10, 11
* 1.8 V, 27 C. Every input is driven through two X1 inverters, every output drives four
* X1 inverters. Sequence: every change of one input in every state of the other inputs (384 transitions),
* 2 ns per state; data are saved from the first transition (2 ns).
* Measurements (LTspice: View > SPICE Error Log):
*   dNN_<output>  delay of the output change in step NN, from the input of the last driver
*                 inverter (node d_<input>) to the 50 % point of the output
*   p_uW          average power in uW, cell and input drivers
*   worst delay = largest dNN value;  PDP = p_uW x worst delay
* Ngspice 46:  worst delay 450.2 ps (d084_P),  power 42.08 uW,  PDP 18.95 fJ
.include tsmc018.lib
.include cells_alu.lib
.options plotwinsize=0
.subckt inv_x1 A Y vdd vss
M0 Y A vss vss nfet w=1u l=0.2u ad=0.5p as=0.5p pd=3u ps=3u
M1 Y A vdd vdd pfet w=2u l=0.2u ad=1p as=1p pd=5u ps=5u
.ends inv_x1
Vcut vcut 0 1.8
Vdrv vdrv 0 1.8
Vld vld 0 1.8
Vs_A s_A 0 PWL(0n 0 2n 0 2.05n 1.8 4n 1.8 4.05n 0 8n 0 8.05n 1.8 10n 1.8 10.05n 0 16n 0 16.05n 1.8 18n 1.8 18.05n 0
+ 22n 0 22.05n 1.8 24n 1.8 24.05n 0 32n 0 32.05n 1.8 34n 1.8 34.05n 0 38n 0 38.05n 1.8 40n 1.8
+ 40.05n 0 46n 0 46.05n 1.8 48n 1.8 48.05n 0 52n 0 52.05n 1.8 54n 1.8 54.05n 0 64n 0 64.05n 1.8
+ 66n 1.8 66.05n 0 70n 0 70.05n 1.8 72n 1.8 72.05n 0 78n 0 78.05n 1.8 80n 1.8 80.05n 0 84n 0
+ 84.05n 1.8 86n 1.8 86.05n 0 94n 0 94.05n 1.8 96n 1.8 96.05n 0 100n 0 100.05n 1.8 102n 1.8 102.05n 0
+ 108n 0 108.05n 1.8 110n 1.8 110.05n 0 114n 0 114.05n 1.8 116n 1.8 116.05n 0 128n 0 128.05n 1.8
+ 130n 1.8 130.05n 0 134n 0 134.05n 1.8 136n 1.8 136.05n 0 142n 0 142.05n 1.8 144n 1.8 144.05n 0
+ 148n 0 148.05n 1.8 150n 1.8 150.05n 0 158n 0 158.05n 1.8 160n 1.8 160.05n 0 164n 0 164.05n 1.8
+ 166n 1.8 166.05n 0 172n 0 172.05n 1.8 174n 1.8 174.05n 0 178n 0 178.05n 1.8 180n 1.8 180.05n 0
+ 190n 0 190.05n 1.8 192n 1.8 192.05n 0 196n 0 196.05n 1.8 198n 1.8 198.05n 0 204n 0 204.05n 1.8
+ 206n 1.8 206.05n 0 210n 0 210.05n 1.8 212n 1.8 212.05n 0 220n 0 220.05n 1.8 222n 1.8 222.05n 0
+ 226n 0 226.05n 1.8 228n 1.8 228.05n 0 234n 0 234.05n 1.8 236n 1.8 236.05n 0 240n 0 240.05n 1.8
+ 562n 1.8 562.05n 0)
Xd1_A s_A d_A vdrv 0 inv_x1
Xd2_A d_A A vdrv 0 inv_x1
Vs_B s_B 0 PWL(0n 0 6n 0 6.05n 1.8 12n 1.8 12.05n 0 20n 0 20.05n 1.8 26n 1.8 26.05n 0 36n 0 36.05n 1.8 42n 1.8
+ 42.05n 0 50n 0 50.05n 1.8 56n 1.8 56.05n 0 68n 0 68.05n 1.8 74n 1.8 74.05n 0 82n 0 82.05n 1.8
+ 88n 1.8 88.05n 0 98n 0 98.05n 1.8 104n 1.8 104.05n 0 112n 0 112.05n 1.8 118n 1.8 118.05n 0 132n 0
+ 132.05n 1.8 138n 1.8 138.05n 0 146n 0 146.05n 1.8 152n 1.8 152.05n 0 162n 0 162.05n 1.8 168n 1.8
+ 168.05n 0 176n 0 176.05n 1.8 182n 1.8 182.05n 0 194n 0 194.05n 1.8 200n 1.8 200.05n 0 208n 0
+ 208.05n 1.8 214n 1.8 214.05n 0 224n 0 224.05n 1.8 230n 1.8 230.05n 0 238n 0 238.05n 1.8 242n 1.8
+ 242.05n 0 244n 0 244.05n 1.8 248n 1.8 248.05n 0 250n 0 250.05n 1.8 256n 1.8 256.05n 0 258n 0
+ 258.05n 1.8 262n 1.8 262.05n 0 264n 0 264.05n 1.8 272n 1.8 272.05n 0 274n 0 274.05n 1.8 278n 1.8
+ 278.05n 0 280n 0 280.05n 1.8 286n 1.8 286.05n 0 288n 0 288.05n 1.8 292n 1.8 292.05n 0 294n 0
+ 294.05n 1.8 304n 1.8 304.05n 0 306n 0 306.05n 1.8 310n 1.8 310.05n 0 312n 0 312.05n 1.8 318n 1.8
+ 318.05n 0 320n 0 320.05n 1.8 324n 1.8 324.05n 0 326n 0 326.05n 1.8 334n 1.8 334.05n 0 336n 0
+ 336.05n 1.8 340n 1.8 340.05n 0 342n 0 342.05n 1.8 348n 1.8 348.05n 0 350n 0 350.05n 1.8 354n 1.8
+ 354.05n 0 484n 0 484.05n 1.8 692n 1.8 692.05n 0)
Xd1_B s_B d_B vdrv 0 inv_x1
Xd2_B d_B B vdrv 0 inv_x1
Vs_C0 s_C0 0 PWL(0n 0 14n 0 14.05n 1.8 28n 1.8 28.05n 0 44n 0 44.05n 1.8 58n 1.8 58.05n 0 76n 0 76.05n 1.8 90n 1.8
+ 90.05n 0 106n 0 106.05n 1.8 120n 1.8 120.05n 0 140n 0 140.05n 1.8 154n 1.8 154.05n 0 170n 0
+ 170.05n 1.8 184n 1.8 184.05n 0 202n 0 202.05n 1.8 216n 1.8 216.05n 0 232n 0 232.05n 1.8 246n 1.8
+ 246.05n 0 252n 0 252.05n 1.8 260n 1.8 260.05n 0 266n 0 266.05n 1.8 276n 1.8 276.05n 0 282n 0
+ 282.05n 1.8 290n 1.8 290.05n 0 296n 0 296.05n 1.8 308n 1.8 308.05n 0 314n 0 314.05n 1.8 322n 1.8
+ 322.05n 0 328n 0 328.05n 1.8 338n 1.8 338.05n 0 344n 0 344.05n 1.8 352n 1.8 352.05n 0 356n 0
+ 356.05n 1.8 358n 1.8 358.05n 0 362n 0 362.05n 1.8 364n 1.8 364.05n 0 370n 0 370.05n 1.8 372n 1.8
+ 372.05n 0 376n 0 376.05n 1.8 378n 1.8 378.05n 0 386n 0 386.05n 1.8 388n 1.8 388.05n 0 392n 0
+ 392.05n 1.8 394n 1.8 394.05n 0 400n 0 400.05n 1.8 402n 1.8 402.05n 0 406n 0 406.05n 1.8 456n 1.8
+ 456.05n 0 534n 0 534.05n 1.8 564n 1.8 564.05n 0 566n 0 566.05n 1.8 570n 1.8 570.05n 0 572n 0
+ 572.05n 1.8 578n 1.8 578.05n 0 580n 0 580.05n 1.8 584n 1.8 584.05n 0 586n 0 586.05n 1.8 594n 1.8
+ 594.05n 0 596n 0 596.05n 1.8 600n 1.8 600.05n 0 602n 0 602.05n 1.8 608n 1.8 608.05n 0 610n 0
+ 610.05n 1.8 614n 1.8 614.05n 0 664n 0 664.05n 1.8 742n 1.8 742.05n 0)
Xd1_C0 s_C0 d_C0 vdrv 0 inv_x1
Xd2_C0 d_C0 C0 vdrv 0 inv_x1
Vs_C1 s_C1 0 PWL(0n 0 30n 0 30.05n 1.8 60n 1.8 60.05n 0 92n 0 92.05n 1.8 122n 1.8 122.05n 0 156n 0 156.05n 1.8
+ 186n 1.8 186.05n 0 218n 0 218.05n 1.8 254n 1.8 254.05n 0 268n 0 268.05n 1.8 284n 1.8 284.05n 0
+ 298n 0 298.05n 1.8 316n 1.8 316.05n 0 330n 0 330.05n 1.8 346n 1.8 346.05n 0 360n 0 360.05n 1.8
+ 366n 1.8 366.05n 0 374n 0 374.05n 1.8 380n 1.8 380.05n 0 390n 0 390.05n 1.8 396n 1.8 396.05n 0
+ 404n 0 404.05n 1.8 408n 1.8 408.05n 0 410n 0 410.05n 1.8 414n 1.8 414.05n 0 416n 0 416.05n 1.8
+ 422n 1.8 422.05n 0 424n 0 424.05n 1.8 428n 1.8 428.05n 0 446n 0 446.05n 1.8 474n 1.8 474.05n 0
+ 486n 0 486.05n 1.8 488n 1.8 488.05n 0 492n 0 492.05n 1.8 494n 1.8 494.05n 0 500n 0 500.05n 1.8
+ 502n 1.8 502.05n 0 506n 0 506.05n 1.8 524n 1.8 524.05n 0 552n 0 552.05n 1.8 568n 1.8 568.05n 0
+ 574n 0 574.05n 1.8 582n 1.8 582.05n 0 588n 0 588.05n 1.8 598n 1.8 598.05n 0 604n 0 604.05n 1.8
+ 612n 1.8 612.05n 0 616n 0 616.05n 1.8 618n 1.8 618.05n 0 622n 0 622.05n 1.8 624n 1.8 624.05n 0
+ 630n 0 630.05n 1.8 632n 1.8 632.05n 0 636n 0 636.05n 1.8 654n 1.8 654.05n 0 682n 0 682.05n 1.8
+ 694n 1.8 694.05n 0 696n 0 696.05n 1.8 700n 1.8 700.05n 0 702n 0 702.05n 1.8 708n 1.8 708.05n 0
+ 710n 0 710.05n 1.8 714n 1.8 714.05n 0 732n 0 732.05n 1.8 760n 1.8 760.05n 0)
Xd1_C1 s_C1 d_C1 vdrv 0 inv_x1
Xd2_C1 d_C1 C1 vdrv 0 inv_x1
Vs_C2 s_C2 0 PWL(0n 0 62n 0 62.05n 1.8 124n 1.8 124.05n 0 188n 0 188.05n 1.8 270n 1.8 270.05n 0 300n 0 300.05n 1.8
+ 332n 1.8 332.05n 0 368n 0 368.05n 1.8 382n 1.8 382.05n 0 398n 0 398.05n 1.8 412n 1.8 412.05n 0
+ 418n 0 418.05n 1.8 426n 1.8 426.05n 0 430n 0 430.05n 1.8 432n 1.8 432.05n 0 436n 0 436.05n 1.8
+ 442n 1.8 442.05n 0 452n 0 452.05n 1.8 458n 1.8 458.05n 0 460n 0 460.05n 1.8 464n 1.8 464.05n 0
+ 470n 0 470.05n 1.8 480n 1.8 480.05n 0 490n 0 490.05n 1.8 496n 1.8 496.05n 0 504n 0 504.05n 1.8
+ 508n 1.8 508.05n 0 510n 0 510.05n 1.8 514n 1.8 514.05n 0 520n 0 520.05n 1.8 530n 1.8 530.05n 0
+ 536n 0 536.05n 1.8 538n 1.8 538.05n 0 542n 0 542.05n 1.8 548n 1.8 548.05n 0 558n 0 558.05n 1.8
+ 576n 1.8 576.05n 0 590n 0 590.05n 1.8 606n 1.8 606.05n 0 620n 0 620.05n 1.8 626n 1.8 626.05n 0
+ 634n 0 634.05n 1.8 638n 1.8 638.05n 0 640n 0 640.05n 1.8 644n 1.8 644.05n 0 650n 0 650.05n 1.8
+ 660n 1.8 660.05n 0 666n 0 666.05n 1.8 668n 1.8 668.05n 0 672n 0 672.05n 1.8 678n 1.8 678.05n 0
+ 688n 0 688.05n 1.8 698n 1.8 698.05n 0 704n 0 704.05n 1.8 712n 1.8 712.05n 0 716n 0 716.05n 1.8
+ 718n 1.8 718.05n 0 722n 0 722.05n 1.8 728n 1.8 728.05n 0 738n 0 738.05n 1.8 744n 1.8 744.05n 0
+ 746n 0 746.05n 1.8 750n 1.8 750.05n 0 756n 0 756.05n 1.8 766n 1.8 766.05n 0)
Xd1_C2 s_C2 d_C2 vdrv 0 inv_x1
Xd2_C2 d_C2 C2 vdrv 0 inv_x1
Vs_C3 s_C3 0 PWL(0n 0 126n 0 126.05n 1.8 302n 1.8 302.05n 0 384n 0 384.05n 1.8 420n 1.8 420.05n 0 434n 0 434.05n 1.8
+ 438n 1.8 438.05n 0 440n 0 440.05n 1.8 444n 1.8 444.05n 0 448n 0 448.05n 1.8 450n 1.8 450.05n 0
+ 454n 0 454.05n 1.8 462n 1.8 462.05n 0 466n 0 466.05n 1.8 468n 1.8 468.05n 0 472n 0 472.05n 1.8
+ 476n 1.8 476.05n 0 478n 0 478.05n 1.8 482n 1.8 482.05n 0 498n 0 498.05n 1.8 512n 1.8 512.05n 0
+ 516n 0 516.05n 1.8 518n 1.8 518.05n 0 522n 0 522.05n 1.8 526n 1.8 526.05n 0 528n 0 528.05n 1.8
+ 532n 1.8 532.05n 0 540n 0 540.05n 1.8 544n 1.8 544.05n 0 546n 0 546.05n 1.8 550n 1.8 550.05n 0
+ 554n 0 554.05n 1.8 556n 1.8 556.05n 0 560n 0 560.05n 1.8 592n 1.8 592.05n 0 628n 0 628.05n 1.8
+ 642n 1.8 642.05n 0 646n 0 646.05n 1.8 648n 1.8 648.05n 0 652n 0 652.05n 1.8 656n 1.8 656.05n 0
+ 658n 0 658.05n 1.8 662n 1.8 662.05n 0 670n 0 670.05n 1.8 674n 1.8 674.05n 0 676n 0 676.05n 1.8
+ 680n 1.8 680.05n 0 684n 0 684.05n 1.8 686n 1.8 686.05n 0 690n 0 690.05n 1.8 706n 1.8 706.05n 0
+ 720n 0 720.05n 1.8 724n 1.8 724.05n 0 726n 0 726.05n 1.8 730n 1.8 730.05n 0 734n 0 734.05n 1.8
+ 736n 1.8 736.05n 0 740n 0 740.05n 1.8 748n 1.8 748.05n 0 752n 0 752.05n 1.8 754n 1.8 754.05n 0
+ 758n 0 758.05n 1.8 762n 1.8 762.05n 0 764n 0 764.05n 1.8 768n 1.8 768.05n 0)
Xd1_C3 s_C3 d_C3 vdrv 0 inv_x1
Xd2_C3 d_C3 C3 vdrv 0 inv_x1
Xcut A B C0 C1 C2 C3 P vcut 0 pl_fb4
Xl_P_0 P ld_P_0 vld 0 inv_x1
Xl_P_1 P ld_P_1 vld 0 inv_x1
Xl_P_2 P ld_P_2 vld 0 inv_x1
Xl_P_3 P ld_P_3 vld 0 inv_x1
Bpw pw 0 V=-(I(Vcut)+I(Vdrv))*1.8e+06
.tran 1p 770n 2n 10p
.meas tran d007_P TRIG V(d_C0) VAL=0.9 TD=14n FALL=1 TARG V(P) VAL=0.9 TD=14n RISE=1
.meas tran d008_P TRIG V(d_A) VAL=0.9 TD=16n FALL=1 TARG V(P) VAL=0.9 TD=16n FALL=1
.meas tran d009_P TRIG V(d_A) VAL=0.9 TD=18n RISE=1 TARG V(P) VAL=0.9 TD=18n RISE=1
.meas tran d010_P TRIG V(d_B) VAL=0.9 TD=20n FALL=1 TARG V(P) VAL=0.9 TD=20n FALL=1
.meas tran d013_P TRIG V(d_B) VAL=0.9 TD=26n RISE=1 TARG V(P) VAL=0.9 TD=26n RISE=1
.meas tran d014_P TRIG V(d_C0) VAL=0.9 TD=28n RISE=1 TARG V(P) VAL=0.9 TD=28n FALL=1
.meas tran d018_P TRIG V(d_B) VAL=0.9 TD=36n FALL=1 TARG V(P) VAL=0.9 TD=36n RISE=1
.meas tran d019_P TRIG V(d_A) VAL=0.9 TD=38n FALL=1 TARG V(P) VAL=0.9 TD=38n FALL=1
.meas tran d020_P TRIG V(d_A) VAL=0.9 TD=40n RISE=1 TARG V(P) VAL=0.9 TD=40n RISE=1
.meas tran d021_P TRIG V(d_B) VAL=0.9 TD=42n RISE=1 TARG V(P) VAL=0.9 TD=42n FALL=1
.meas tran d022_P TRIG V(d_C0) VAL=0.9 TD=44n FALL=1 TARG V(P) VAL=0.9 TD=44n RISE=1
.meas tran d023_P TRIG V(d_A) VAL=0.9 TD=46n FALL=1 TARG V(P) VAL=0.9 TD=46n FALL=1
.meas tran d024_P TRIG V(d_A) VAL=0.9 TD=48n RISE=1 TARG V(P) VAL=0.9 TD=48n RISE=1
.meas tran d026_P TRIG V(d_A) VAL=0.9 TD=52n FALL=1 TARG V(P) VAL=0.9 TD=52n FALL=1
.meas tran d027_P TRIG V(d_A) VAL=0.9 TD=54n RISE=1 TARG V(P) VAL=0.9 TD=54n RISE=1
.meas tran d029_P TRIG V(d_C0) VAL=0.9 TD=58n RISE=1 TARG V(P) VAL=0.9 TD=58n FALL=1
.meas tran d032_P TRIG V(d_A) VAL=0.9 TD=64n FALL=1 TARG V(P) VAL=0.9 TD=64n RISE=1
.meas tran d033_P TRIG V(d_A) VAL=0.9 TD=66n RISE=1 TARG V(P) VAL=0.9 TD=66n FALL=1
.meas tran d038_P TRIG V(d_C0) VAL=0.9 TD=76n FALL=1 TARG V(P) VAL=0.9 TD=76n RISE=1
.meas tran d041_P TRIG V(d_B) VAL=0.9 TD=82n FALL=1 TARG V(P) VAL=0.9 TD=82n FALL=1
.meas tran d044_P TRIG V(d_B) VAL=0.9 TD=88n RISE=1 TARG V(P) VAL=0.9 TD=88n RISE=1
.meas tran d045_P TRIG V(d_C0) VAL=0.9 TD=90n RISE=1 TARG V(P) VAL=0.9 TD=90n FALL=1
.meas tran d047_P TRIG V(d_A) VAL=0.9 TD=94n FALL=1 TARG V(P) VAL=0.9 TD=94n RISE=1
.meas tran d048_P TRIG V(d_A) VAL=0.9 TD=96n RISE=1 TARG V(P) VAL=0.9 TD=96n FALL=1
.meas tran d049_P TRIG V(d_B) VAL=0.9 TD=98n FALL=1 TARG V(P) VAL=0.9 TD=98n RISE=1
.meas tran d050_P TRIG V(d_A) VAL=0.9 TD=100n FALL=1 TARG V(P) VAL=0.9 TD=100n FALL=1
.meas tran d051_P TRIG V(d_A) VAL=0.9 TD=102n RISE=1 TARG V(P) VAL=0.9 TD=102n RISE=1
.meas tran d052_P TRIG V(d_B) VAL=0.9 TD=104n RISE=1 TARG V(P) VAL=0.9 TD=104n FALL=1
.meas tran d053_P TRIG V(d_C0) VAL=0.9 TD=106n FALL=1 TARG V(P) VAL=0.9 TD=106n RISE=1
.meas tran d057_P TRIG V(d_A) VAL=0.9 TD=114n FALL=1 TARG V(P) VAL=0.9 TD=114n FALL=1
.meas tran d058_P TRIG V(d_A) VAL=0.9 TD=116n RISE=1 TARG V(P) VAL=0.9 TD=116n RISE=1
.meas tran d060_P TRIG V(d_C0) VAL=0.9 TD=120n RISE=1 TARG V(P) VAL=0.9 TD=120n FALL=1
.meas tran d067_P TRIG V(d_A) VAL=0.9 TD=134n FALL=1 TARG V(P) VAL=0.9 TD=134n RISE=1
.meas tran d068_P TRIG V(d_A) VAL=0.9 TD=136n RISE=1 TARG V(P) VAL=0.9 TD=136n FALL=1
.meas tran d070_P TRIG V(d_C0) VAL=0.9 TD=140n FALL=1 TARG V(P) VAL=0.9 TD=140n RISE=1
.meas tran d071_P TRIG V(d_A) VAL=0.9 TD=142n FALL=1 TARG V(P) VAL=0.9 TD=142n FALL=1
.meas tran d072_P TRIG V(d_A) VAL=0.9 TD=144n RISE=1 TARG V(P) VAL=0.9 TD=144n RISE=1
.meas tran d073_P TRIG V(d_B) VAL=0.9 TD=146n FALL=1 TARG V(P) VAL=0.9 TD=146n FALL=1
.meas tran d074_P TRIG V(d_A) VAL=0.9 TD=148n FALL=1 TARG V(P) VAL=0.9 TD=148n RISE=1
.meas tran d075_P TRIG V(d_A) VAL=0.9 TD=150n RISE=1 TARG V(P) VAL=0.9 TD=150n FALL=1
.meas tran d076_P TRIG V(d_B) VAL=0.9 TD=152n RISE=1 TARG V(P) VAL=0.9 TD=152n RISE=1
.meas tran d077_P TRIG V(d_C0) VAL=0.9 TD=154n RISE=1 TARG V(P) VAL=0.9 TD=154n FALL=1
.meas tran d081_P TRIG V(d_B) VAL=0.9 TD=162n FALL=1 TARG V(P) VAL=0.9 TD=162n RISE=1
.meas tran d084_P TRIG V(d_B) VAL=0.9 TD=168n RISE=1 TARG V(P) VAL=0.9 TD=168n FALL=1
.meas tran d085_P TRIG V(d_C0) VAL=0.9 TD=170n FALL=1 TARG V(P) VAL=0.9 TD=170n RISE=1
.meas tran d086_P TRIG V(d_A) VAL=0.9 TD=172n FALL=1 TARG V(P) VAL=0.9 TD=172n FALL=1
.meas tran d087_P TRIG V(d_A) VAL=0.9 TD=174n RISE=1 TARG V(P) VAL=0.9 TD=174n RISE=1
.meas tran d092_P TRIG V(d_C0) VAL=0.9 TD=184n RISE=1 TARG V(P) VAL=0.9 TD=184n FALL=1
.meas tran d095_P TRIG V(d_A) VAL=0.9 TD=190n FALL=1 TARG V(P) VAL=0.9 TD=190n RISE=1
.meas tran d096_P TRIG V(d_A) VAL=0.9 TD=192n RISE=1 TARG V(P) VAL=0.9 TD=192n FALL=1
.meas tran d098_P TRIG V(d_A) VAL=0.9 TD=196n FALL=1 TARG V(P) VAL=0.9 TD=196n RISE=1
.meas tran d099_P TRIG V(d_A) VAL=0.9 TD=198n RISE=1 TARG V(P) VAL=0.9 TD=198n FALL=1
.meas tran d101_P TRIG V(d_C0) VAL=0.9 TD=202n FALL=1 TARG V(P) VAL=0.9 TD=202n RISE=1
.meas tran d104_P TRIG V(d_B) VAL=0.9 TD=208n FALL=1 TARG V(P) VAL=0.9 TD=208n FALL=1
.meas tran d105_P TRIG V(d_A) VAL=0.9 TD=210n FALL=1 TARG V(P) VAL=0.9 TD=210n RISE=1
.meas tran d106_P TRIG V(d_A) VAL=0.9 TD=212n RISE=1 TARG V(P) VAL=0.9 TD=212n FALL=1
.meas tran d107_P TRIG V(d_B) VAL=0.9 TD=214n RISE=1 TARG V(P) VAL=0.9 TD=214n RISE=1
.meas tran d108_P TRIG V(d_C0) VAL=0.9 TD=216n RISE=1 TARG V(P) VAL=0.9 TD=216n FALL=1
.meas tran d110_P TRIG V(d_A) VAL=0.9 TD=220n FALL=1 TARG V(P) VAL=0.9 TD=220n RISE=1
.meas tran d111_P TRIG V(d_A) VAL=0.9 TD=222n RISE=1 TARG V(P) VAL=0.9 TD=222n FALL=1
.meas tran d112_P TRIG V(d_B) VAL=0.9 TD=224n FALL=1 TARG V(P) VAL=0.9 TD=224n RISE=1
.meas tran d115_P TRIG V(d_B) VAL=0.9 TD=230n RISE=1 TARG V(P) VAL=0.9 TD=230n FALL=1
.meas tran d116_P TRIG V(d_C0) VAL=0.9 TD=232n FALL=1 TARG V(P) VAL=0.9 TD=232n RISE=1
.meas tran d136_P TRIG V(d_B) VAL=0.9 TD=272n RISE=1 TARG V(P) VAL=0.9 TD=272n FALL=1
.meas tran d137_P TRIG V(d_B) VAL=0.9 TD=274n FALL=1 TARG V(P) VAL=0.9 TD=274n RISE=1
.meas tran d139_P TRIG V(d_B) VAL=0.9 TD=278n RISE=1 TARG V(P) VAL=0.9 TD=278n FALL=1
.meas tran d140_P TRIG V(d_B) VAL=0.9 TD=280n FALL=1 TARG V(P) VAL=0.9 TD=280n RISE=1
.meas tran d143_P TRIG V(d_B) VAL=0.9 TD=286n RISE=1 TARG V(P) VAL=0.9 TD=286n FALL=1
.meas tran d144_P TRIG V(d_B) VAL=0.9 TD=288n FALL=1 TARG V(P) VAL=0.9 TD=288n RISE=1
.meas tran d146_P TRIG V(d_B) VAL=0.9 TD=292n RISE=1 TARG V(P) VAL=0.9 TD=292n FALL=1
.meas tran d147_P TRIG V(d_B) VAL=0.9 TD=294n FALL=1 TARG V(P) VAL=0.9 TD=294n RISE=1
.meas tran d151_P TRIG V(d_C3) VAL=0.9 TD=302n RISE=1 TARG V(P) VAL=0.9 TD=302n FALL=1
.meas tran d152_P TRIG V(d_B) VAL=0.9 TD=304n RISE=1 TARG V(P) VAL=0.9 TD=304n RISE=1
.meas tran d153_P TRIG V(d_B) VAL=0.9 TD=306n FALL=1 TARG V(P) VAL=0.9 TD=306n FALL=1
.meas tran d155_P TRIG V(d_B) VAL=0.9 TD=310n RISE=1 TARG V(P) VAL=0.9 TD=310n RISE=1
.meas tran d156_P TRIG V(d_B) VAL=0.9 TD=312n FALL=1 TARG V(P) VAL=0.9 TD=312n FALL=1
.meas tran d159_P TRIG V(d_B) VAL=0.9 TD=318n RISE=1 TARG V(P) VAL=0.9 TD=318n RISE=1
.meas tran d160_P TRIG V(d_B) VAL=0.9 TD=320n FALL=1 TARG V(P) VAL=0.9 TD=320n FALL=1
.meas tran d162_P TRIG V(d_B) VAL=0.9 TD=324n RISE=1 TARG V(P) VAL=0.9 TD=324n RISE=1
.meas tran d163_P TRIG V(d_B) VAL=0.9 TD=326n FALL=1 TARG V(P) VAL=0.9 TD=326n FALL=1
.meas tran d184_P TRIG V(d_C2) VAL=0.9 TD=368n FALL=1 TARG V(P) VAL=0.9 TD=368n RISE=1
.meas tran d191_P TRIG V(d_C2) VAL=0.9 TD=382n RISE=1 TARG V(P) VAL=0.9 TD=382n FALL=1
.meas tran d199_P TRIG V(d_C2) VAL=0.9 TD=398n FALL=1 TARG V(P) VAL=0.9 TD=398n RISE=1
.meas tran d206_P TRIG V(d_C2) VAL=0.9 TD=412n RISE=1 TARG V(P) VAL=0.9 TD=412n FALL=1
.meas tran d209_P TRIG V(d_C2) VAL=0.9 TD=418n FALL=1 TARG V(P) VAL=0.9 TD=418n RISE=1
.meas tran d213_P TRIG V(d_C2) VAL=0.9 TD=426n RISE=1 TARG V(P) VAL=0.9 TD=426n FALL=1
.meas tran d215_P TRIG V(d_C2) VAL=0.9 TD=430n FALL=1 TARG V(P) VAL=0.9 TD=430n RISE=1
.meas tran d216_P TRIG V(d_C2) VAL=0.9 TD=432n RISE=1 TARG V(P) VAL=0.9 TD=432n FALL=1
.meas tran d218_P TRIG V(d_C2) VAL=0.9 TD=436n FALL=1 TARG V(P) VAL=0.9 TD=436n RISE=1
.meas tran d221_P TRIG V(d_C2) VAL=0.9 TD=442n RISE=1 TARG V(P) VAL=0.9 TD=442n FALL=1
.meas tran d226_P TRIG V(d_C2) VAL=0.9 TD=452n FALL=1 TARG V(P) VAL=0.9 TD=452n RISE=1
.meas tran d229_P TRIG V(d_C2) VAL=0.9 TD=458n RISE=1 TARG V(P) VAL=0.9 TD=458n FALL=1
.meas tran d230_P TRIG V(d_C2) VAL=0.9 TD=460n FALL=1 TARG V(P) VAL=0.9 TD=460n RISE=1
.meas tran d232_P TRIG V(d_C2) VAL=0.9 TD=464n RISE=1 TARG V(P) VAL=0.9 TD=464n FALL=1
.meas tran d235_P TRIG V(d_C2) VAL=0.9 TD=470n FALL=1 TARG V(P) VAL=0.9 TD=470n RISE=1
.meas tran d240_P TRIG V(d_C2) VAL=0.9 TD=480n RISE=1 TARG V(P) VAL=0.9 TD=480n FALL=1
.meas tran d249_P TRIG V(d_C3) VAL=0.9 TD=498n FALL=1 TARG V(P) VAL=0.9 TD=498n RISE=1
.meas tran d256_P TRIG V(d_C3) VAL=0.9 TD=512n RISE=1 TARG V(P) VAL=0.9 TD=512n FALL=1
.meas tran d258_P TRIG V(d_C3) VAL=0.9 TD=516n FALL=1 TARG V(P) VAL=0.9 TD=516n RISE=1
.meas tran d259_P TRIG V(d_C3) VAL=0.9 TD=518n RISE=1 TARG V(P) VAL=0.9 TD=518n FALL=1
.meas tran d261_P TRIG V(d_C3) VAL=0.9 TD=522n FALL=1 TARG V(P) VAL=0.9 TD=522n RISE=1
.meas tran d263_P TRIG V(d_C3) VAL=0.9 TD=526n RISE=1 TARG V(P) VAL=0.9 TD=526n FALL=1
.meas tran d264_P TRIG V(d_C3) VAL=0.9 TD=528n FALL=1 TARG V(P) VAL=0.9 TD=528n RISE=1
.meas tran d266_P TRIG V(d_C3) VAL=0.9 TD=532n RISE=1 TARG V(P) VAL=0.9 TD=532n FALL=1
.meas tran d270_P TRIG V(d_C3) VAL=0.9 TD=540n FALL=1 TARG V(P) VAL=0.9 TD=540n RISE=1
.meas tran d272_P TRIG V(d_C3) VAL=0.9 TD=544n RISE=1 TARG V(P) VAL=0.9 TD=544n FALL=1
.meas tran d273_P TRIG V(d_C3) VAL=0.9 TD=546n FALL=1 TARG V(P) VAL=0.9 TD=546n RISE=1
.meas tran d275_P TRIG V(d_C3) VAL=0.9 TD=550n RISE=1 TARG V(P) VAL=0.9 TD=550n FALL=1
.meas tran d277_P TRIG V(d_C3) VAL=0.9 TD=554n FALL=1 TARG V(P) VAL=0.9 TD=554n RISE=1
.meas tran d278_P TRIG V(d_C3) VAL=0.9 TD=556n RISE=1 TARG V(P) VAL=0.9 TD=556n FALL=1
.meas tran d280_P TRIG V(d_C3) VAL=0.9 TD=560n FALL=1 TARG V(P) VAL=0.9 TD=560n RISE=1
.meas tran d284_P TRIG V(d_C1) VAL=0.9 TD=568n RISE=1 TARG V(P) VAL=0.9 TD=568n FALL=1
.meas tran d287_P TRIG V(d_C1) VAL=0.9 TD=574n FALL=1 TARG V(P) VAL=0.9 TD=574n RISE=1
.meas tran d291_P TRIG V(d_C1) VAL=0.9 TD=582n RISE=1 TARG V(P) VAL=0.9 TD=582n FALL=1
.meas tran d294_P TRIG V(d_C1) VAL=0.9 TD=588n FALL=1 TARG V(P) VAL=0.9 TD=588n RISE=1
.meas tran d299_P TRIG V(d_C1) VAL=0.9 TD=598n RISE=1 TARG V(P) VAL=0.9 TD=598n FALL=1
.meas tran d302_P TRIG V(d_C1) VAL=0.9 TD=604n FALL=1 TARG V(P) VAL=0.9 TD=604n RISE=1
.meas tran d306_P TRIG V(d_C1) VAL=0.9 TD=612n RISE=1 TARG V(P) VAL=0.9 TD=612n FALL=1
.meas tran d308_P TRIG V(d_C1) VAL=0.9 TD=616n FALL=1 TARG V(P) VAL=0.9 TD=616n RISE=1
.meas tran d309_P TRIG V(d_C1) VAL=0.9 TD=618n RISE=1 TARG V(P) VAL=0.9 TD=618n FALL=1
.meas tran d311_P TRIG V(d_C1) VAL=0.9 TD=622n FALL=1 TARG V(P) VAL=0.9 TD=622n RISE=1
.meas tran d312_P TRIG V(d_C1) VAL=0.9 TD=624n RISE=1 TARG V(P) VAL=0.9 TD=624n FALL=1
.meas tran d315_P TRIG V(d_C1) VAL=0.9 TD=630n FALL=1 TARG V(P) VAL=0.9 TD=630n RISE=1
.meas tran d316_P TRIG V(d_C1) VAL=0.9 TD=632n RISE=1 TARG V(P) VAL=0.9 TD=632n FALL=1
.meas tran d318_P TRIG V(d_C1) VAL=0.9 TD=636n FALL=1 TARG V(P) VAL=0.9 TD=636n RISE=1
.meas tran d327_P TRIG V(d_C1) VAL=0.9 TD=654n RISE=1 TARG V(P) VAL=0.9 TD=654n FALL=1
.meas tran d341_P TRIG V(d_C1) VAL=0.9 TD=682n FALL=1 TARG V(P) VAL=0.9 TD=682n RISE=1
.meas tran d371_P TRIG V(d_C0) VAL=0.9 TD=742n RISE=1 TARG V(P) VAL=0.9 TD=742n FALL=1
.meas tran p_uW AVG V(pw)
.end
