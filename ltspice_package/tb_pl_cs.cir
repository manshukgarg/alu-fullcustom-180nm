* tb_pl_cs.cir  test of cell pl_cs (CS, 24 transistors)
* Function: CO = CI if P = 1, else A;  Y = P if K = 1, else P xor CI
* 1.8 V, 27 C. Every input is driven through two X1 inverters, every output drives four
* X1 inverters. Sequence: every change of one input in every state of the other inputs (64 transitions),
* 2 ns per state; data are saved from the first transition (2 ns).
* Measurements (LTspice: View > SPICE Error Log):
*   dNN_<output>  delay of the output change in step NN, from the input of the last driver
*                 inverter (node d_<input>) to the 50 % point of the output
*   p_uW          average power in uW, cell and input drivers
*   worst delay = largest dNN value;  PDP = p_uW x worst delay
* Ngspice 46:  worst delay 458.6 ps (d14_Y),  power 73.36 uW,  PDP 33.64 fJ
.include tsmc018.lib
.include cells_alu.lib
.options plotwinsize=0
.subckt inv_x1 A Y vdd vss
M0 Y A vss vss nfet w=1u l=0.2u ad=0.5p as=0.5p pd=3u ps=3u
M1 Y A vdd vdd pfet w=2u l=0.2u ad=1p as=1p pd=5u ps=5u
.ends inv_x1
Vcut vcut 0 1.8
Vdrv vdrv 0 1.8
Vld vld 0 1.8
Vs_P s_P 0 PWL(0n 0 2n 0 2.05n 1.8 4n 1.8 4.05n 0 8n 0 8.05n 1.8 10n 1.8 10.05n 0 16n 0 16.05n 1.8 18n 1.8 18.05n 0
+ 22n 0 22.05n 1.8 24n 1.8 24.05n 0 32n 0 32.05n 1.8 34n 1.8 34.05n 0 38n 0 38.05n 1.8 40n 1.8
+ 40.05n 0 46n 0 46.05n 1.8 48n 1.8 48.05n 0 52n 0 52.05n 1.8 102n 1.8 102.05n 0)
Xd1_P s_P d_P vdrv 0 inv_x1
Xd2_P d_P P vdrv 0 inv_x1
Vs_A s_A 0 PWL(0n 0 6n 0 6.05n 1.8 12n 1.8 12.05n 0 20n 0 20.05n 1.8 26n 1.8 26.05n 0 36n 0 36.05n 1.8 42n 1.8
+ 42.05n 0 50n 0 50.05n 1.8 54n 1.8 54.05n 0 56n 0 56.05n 1.8 60n 1.8 60.05n 0 62n 0 62.05n 1.8
+ 68n 1.8 68.05n 0 70n 0 70.05n 1.8 74n 1.8 74.05n 0 92n 0 92.05n 1.8 120n 1.8 120.05n 0)
Xd1_A s_A d_A vdrv 0 inv_x1
Xd2_A d_A A vdrv 0 inv_x1
Vs_CI s_CI 0 PWL(0n 0 14n 0 14.05n 1.8 28n 1.8 28.05n 0 44n 0 44.05n 1.8 58n 1.8 58.05n 0 64n 0 64.05n 1.8 72n 1.8
+ 72.05n 0 76n 0 76.05n 1.8 78n 1.8 78.05n 0 82n 0 82.05n 1.8 88n 1.8 88.05n 0 98n 0 98.05n 1.8
+ 104n 1.8 104.05n 0 106n 0 106.05n 1.8 110n 1.8 110.05n 0 116n 0 116.05n 1.8 126n 1.8 126.05n 0)
Xd1_CI s_CI d_CI vdrv 0 inv_x1
Xd2_CI d_CI CI vdrv 0 inv_x1
Vs_K s_K 0 PWL(0n 0 30n 0 30.05n 1.8 66n 1.8 66.05n 0 80n 0 80.05n 1.8 84n 1.8 84.05n 0 86n 0 86.05n 1.8 90n 1.8
+ 90.05n 0 94n 0 94.05n 1.8 96n 1.8 96.05n 0 100n 0 100.05n 1.8 108n 1.8 108.05n 0 112n 0 112.05n 1.8
+ 114n 1.8 114.05n 0 118n 0 118.05n 1.8 122n 1.8 122.05n 0 124n 0 124.05n 1.8 128n 1.8 128.05n 0)
Xd1_K s_K d_K vdrv 0 inv_x1
Xd2_K d_K K vdrv 0 inv_x1
Xcut P A CI K CO Y vcut 0 pl_cs
Xl_CO_0 CO ld_CO_0 vld 0 inv_x1
Xl_CO_1 CO ld_CO_1 vld 0 inv_x1
Xl_CO_2 CO ld_CO_2 vld 0 inv_x1
Xl_CO_3 CO ld_CO_3 vld 0 inv_x1
Xl_Y_0 Y ld_Y_0 vld 0 inv_x1
Xl_Y_1 Y ld_Y_1 vld 0 inv_x1
Xl_Y_2 Y ld_Y_2 vld 0 inv_x1
Xl_Y_3 Y ld_Y_3 vld 0 inv_x1
Bpw pw 0 V=-(I(Vcut)+I(Vdrv))*1.8e+06
.tran 1p 130n 2n 10p
.meas tran d01_Y TRIG V(d_P) VAL=0.9 TD=2n FALL=1 TARG V(Y) VAL=0.9 TD=2n RISE=1
.meas tran d02_Y TRIG V(d_P) VAL=0.9 TD=4n RISE=1 TARG V(Y) VAL=0.9 TD=4n FALL=1
.meas tran d03_CO TRIG V(d_A) VAL=0.9 TD=6n FALL=1 TARG V(CO) VAL=0.9 TD=6n RISE=1
.meas tran d04_CO TRIG V(d_P) VAL=0.9 TD=8n FALL=1 TARG V(CO) VAL=0.9 TD=8n FALL=1
.meas tran d04_Y TRIG V(d_P) VAL=0.9 TD=8n FALL=1 TARG V(Y) VAL=0.9 TD=8n RISE=1
.meas tran d05_CO TRIG V(d_P) VAL=0.9 TD=10n RISE=1 TARG V(CO) VAL=0.9 TD=10n RISE=1
.meas tran d05_Y TRIG V(d_P) VAL=0.9 TD=10n RISE=1 TARG V(Y) VAL=0.9 TD=10n FALL=1
.meas tran d06_CO TRIG V(d_A) VAL=0.9 TD=12n RISE=1 TARG V(CO) VAL=0.9 TD=12n FALL=1
.meas tran d07_Y TRIG V(d_CI) VAL=0.9 TD=14n FALL=1 TARG V(Y) VAL=0.9 TD=14n RISE=1
.meas tran d08_CO TRIG V(d_P) VAL=0.9 TD=16n FALL=1 TARG V(CO) VAL=0.9 TD=16n RISE=1
.meas tran d08_Y TRIG V(d_P) VAL=0.9 TD=16n FALL=1 TARG V(Y) VAL=0.9 TD=16n FALL=1
.meas tran d09_CO TRIG V(d_P) VAL=0.9 TD=18n RISE=1 TARG V(CO) VAL=0.9 TD=18n FALL=1
.meas tran d09_Y TRIG V(d_P) VAL=0.9 TD=18n RISE=1 TARG V(Y) VAL=0.9 TD=18n RISE=1
.meas tran d10_CO TRIG V(d_A) VAL=0.9 TD=20n FALL=1 TARG V(CO) VAL=0.9 TD=20n RISE=1
.meas tran d11_Y TRIG V(d_P) VAL=0.9 TD=22n FALL=1 TARG V(Y) VAL=0.9 TD=22n FALL=1
.meas tran d12_Y TRIG V(d_P) VAL=0.9 TD=24n RISE=1 TARG V(Y) VAL=0.9 TD=24n RISE=1
.meas tran d13_CO TRIG V(d_A) VAL=0.9 TD=26n RISE=1 TARG V(CO) VAL=0.9 TD=26n FALL=1
.meas tran d14_Y TRIG V(d_CI) VAL=0.9 TD=28n RISE=1 TARG V(Y) VAL=0.9 TD=28n FALL=1
.meas tran d16_Y TRIG V(d_P) VAL=0.9 TD=32n FALL=1 TARG V(Y) VAL=0.9 TD=32n RISE=1
.meas tran d17_Y TRIG V(d_P) VAL=0.9 TD=34n RISE=1 TARG V(Y) VAL=0.9 TD=34n FALL=1
.meas tran d18_CO TRIG V(d_A) VAL=0.9 TD=36n FALL=1 TARG V(CO) VAL=0.9 TD=36n RISE=1
.meas tran d19_CO TRIG V(d_P) VAL=0.9 TD=38n FALL=1 TARG V(CO) VAL=0.9 TD=38n FALL=1
.meas tran d19_Y TRIG V(d_P) VAL=0.9 TD=38n FALL=1 TARG V(Y) VAL=0.9 TD=38n RISE=1
.meas tran d20_CO TRIG V(d_P) VAL=0.9 TD=40n RISE=1 TARG V(CO) VAL=0.9 TD=40n RISE=1
.meas tran d20_Y TRIG V(d_P) VAL=0.9 TD=40n RISE=1 TARG V(Y) VAL=0.9 TD=40n FALL=1
.meas tran d21_CO TRIG V(d_A) VAL=0.9 TD=42n RISE=1 TARG V(CO) VAL=0.9 TD=42n FALL=1
.meas tran d23_CO TRIG V(d_P) VAL=0.9 TD=46n FALL=1 TARG V(CO) VAL=0.9 TD=46n RISE=1
.meas tran d23_Y TRIG V(d_P) VAL=0.9 TD=46n FALL=1 TARG V(Y) VAL=0.9 TD=46n RISE=1
.meas tran d24_CO TRIG V(d_P) VAL=0.9 TD=48n RISE=1 TARG V(CO) VAL=0.9 TD=48n FALL=1
.meas tran d24_Y TRIG V(d_P) VAL=0.9 TD=48n RISE=1 TARG V(Y) VAL=0.9 TD=48n FALL=1
.meas tran d25_CO TRIG V(d_A) VAL=0.9 TD=50n FALL=1 TARG V(CO) VAL=0.9 TD=50n RISE=1
.meas tran d26_Y TRIG V(d_P) VAL=0.9 TD=52n FALL=1 TARG V(Y) VAL=0.9 TD=52n RISE=1
.meas tran d29_CO TRIG V(d_CI) VAL=0.9 TD=58n RISE=1 TARG V(CO) VAL=0.9 TD=58n FALL=1
.meas tran d32_CO TRIG V(d_CI) VAL=0.9 TD=64n FALL=1 TARG V(CO) VAL=0.9 TD=64n RISE=1
.meas tran d33_Y TRIG V(d_K) VAL=0.9 TD=66n RISE=1 TARG V(Y) VAL=0.9 TD=66n FALL=1
.meas tran d36_CO TRIG V(d_CI) VAL=0.9 TD=72n RISE=1 TARG V(CO) VAL=0.9 TD=72n FALL=1
.meas tran d36_Y TRIG V(d_CI) VAL=0.9 TD=72n RISE=1 TARG V(Y) VAL=0.9 TD=72n RISE=1
.meas tran d38_CO TRIG V(d_CI) VAL=0.9 TD=76n FALL=1 TARG V(CO) VAL=0.9 TD=76n RISE=1
.meas tran d38_Y TRIG V(d_CI) VAL=0.9 TD=76n FALL=1 TARG V(Y) VAL=0.9 TD=76n FALL=1
.meas tran d39_CO TRIG V(d_CI) VAL=0.9 TD=78n RISE=1 TARG V(CO) VAL=0.9 TD=78n FALL=1
.meas tran d39_Y TRIG V(d_CI) VAL=0.9 TD=78n RISE=1 TARG V(Y) VAL=0.9 TD=78n RISE=1
.meas tran d41_CO TRIG V(d_CI) VAL=0.9 TD=82n FALL=1 TARG V(CO) VAL=0.9 TD=82n RISE=1
.meas tran d42_Y TRIG V(d_K) VAL=0.9 TD=84n RISE=1 TARG V(Y) VAL=0.9 TD=84n FALL=1
.meas tran d43_Y TRIG V(d_K) VAL=0.9 TD=86n FALL=1 TARG V(Y) VAL=0.9 TD=86n RISE=1
.meas tran d44_CO TRIG V(d_CI) VAL=0.9 TD=88n RISE=1 TARG V(CO) VAL=0.9 TD=88n FALL=1
.meas tran d49_CO TRIG V(d_CI) VAL=0.9 TD=98n FALL=1 TARG V(CO) VAL=0.9 TD=98n RISE=1
.meas tran d49_Y TRIG V(d_CI) VAL=0.9 TD=98n FALL=1 TARG V(Y) VAL=0.9 TD=98n FALL=1
.meas tran d50_Y TRIG V(d_K) VAL=0.9 TD=100n FALL=1 TARG V(Y) VAL=0.9 TD=100n RISE=1
.meas tran d51_Y TRIG V(d_P) VAL=0.9 TD=102n RISE=1 TARG V(Y) VAL=0.9 TD=102n FALL=1
.meas tran d54_Y TRIG V(d_K) VAL=0.9 TD=108n RISE=1 TARG V(Y) VAL=0.9 TD=108n RISE=1
.meas tran d55_Y TRIG V(d_CI) VAL=0.9 TD=110n RISE=1 TARG V(Y) VAL=0.9 TD=110n FALL=1
.meas tran d58_Y TRIG V(d_CI) VAL=0.9 TD=116n FALL=1 TARG V(Y) VAL=0.9 TD=116n RISE=1
.meas tran d59_Y TRIG V(d_K) VAL=0.9 TD=118n FALL=1 TARG V(Y) VAL=0.9 TD=118n FALL=1
.meas tran d60_CO TRIG V(d_A) VAL=0.9 TD=120n RISE=1 TARG V(CO) VAL=0.9 TD=120n FALL=1
.meas tran d61_Y TRIG V(d_K) VAL=0.9 TD=122n RISE=1 TARG V(Y) VAL=0.9 TD=122n RISE=1
.meas tran d62_Y TRIG V(d_K) VAL=0.9 TD=124n FALL=1 TARG V(Y) VAL=0.9 TD=124n FALL=1
.meas tran p_uW AVG V(pw)
.end
