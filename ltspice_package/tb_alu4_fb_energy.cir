* tb_alu4_fb_energy.cir  energy per operation of the 4-bit ALU, proposed: FB4 and CS cell per bit, pl018 cells for decoder and flags
* 200 vectors of 5 ns: for each of the 8 operations one change to the operation and then
* 24 random operand changes. V(win) is 1 during the 192 random operand changes; the energy
* drawn from the ALU supply during them, divided by 192, is the energy per operation.
* Data are saved from 5 ns. Measurement:
*   e_op_fJ   energy per operation in fJ (average over the 8 operations)
* Ngspice 46 (project flow): 870.6 fJ
.include tsmc018.lib
.include cells_pl.lib
.include cells_alu.lib
.include alu4_fb.lib
.options plotwinsize=0
.subckt inv_x1 A Y vdd vss
M0 Y A vss vss nfet w=1u l=0.2u ad=0.5p as=0.5p pd=3u ps=3u
M1 Y A vdd vdd pfet w=2u l=0.2u ad=1p as=1p pd=5u ps=5u
.ends inv_x1
Vdut vdd_dut 0 1.8
Vdrv vdrv 0 1.8
Vld vld 0 1.8
Vs_a_0 s_a_0 0 PWL(0n 0 15n 0 15.05n 1.8 25n 1.8 25.05n 0 30n 0 30.05n 1.8 35n 1.8 35.05n 0 50n 0 50.05n 1.8 55n 1.8
+ 55.05n 0 65n 0 65.05n 1.8 145n 1.8 145.05n 0 150n 0 150.05n 1.8 155n 1.8 155.05n 0 160n 0
+ 160.05n 1.8 185n 1.8 185.05n 0 195n 0 195.05n 1.8 200n 1.8 200.05n 0 215n 0 215.05n 1.8 240n 1.8
+ 240.05n 0 250n 0 250.05n 1.8 255n 1.8 255.05n 0 260n 0 260.05n 1.8 265n 1.8 265.05n 0 285n 0
+ 285.05n 1.8 300n 1.8 300.05n 0 315n 0 315.05n 1.8 330n 1.8 330.05n 0 340n 0 340.05n 1.8 345n 1.8
+ 345.05n 0 365n 0 365.05n 1.8 375n 1.8 375.05n 0 390n 0 390.05n 1.8 395n 1.8 395.05n 0 400n 0
+ 400.05n 1.8 405n 1.8 405.05n 0 410n 0 410.05n 1.8 420n 1.8 420.05n 0 435n 0 435.05n 1.8 440n 1.8
+ 440.05n 0 445n 0 445.05n 1.8 450n 1.8 450.05n 0 460n 0 460.05n 1.8 470n 1.8 470.05n 0 495n 0
+ 495.05n 1.8 500n 1.8 500.05n 0 510n 0 510.05n 1.8 515n 1.8 515.05n 0 525n 0 525.05n 1.8 530n 1.8
+ 530.05n 0 540n 0 540.05n 1.8 545n 1.8 545.05n 0 550n 0 550.05n 1.8 570n 1.8 570.05n 0 590n 0
+ 590.05n 1.8 595n 1.8 595.05n 0 600n 0 600.05n 1.8 605n 1.8 605.05n 0 610n 0 610.05n 1.8 620n 1.8
+ 620.05n 0 625n 0 625.05n 1.8 645n 1.8 645.05n 0 650n 0 650.05n 1.8 660n 1.8 660.05n 0 680n 0
+ 680.05n 1.8 685n 1.8 685.05n 0 720n 0 720.05n 1.8 725n 1.8 725.05n 0 740n 0 740.05n 1.8 745n 1.8
+ 745.05n 0 765n 0 765.05n 1.8 780n 1.8 780.05n 0 790n 0 790.05n 1.8 800n 1.8 800.05n 0 815n 0
+ 815.05n 1.8 825n 1.8 825.05n 0 835n 0 835.05n 1.8 840n 1.8 840.05n 0 850n 0 850.05n 1.8 855n 1.8
+ 855.05n 0 870n 0 870.05n 1.8 885n 1.8 885.05n 0 910n 0 910.05n 1.8 930n 1.8 930.05n 0 955n 0
+ 955.05n 1.8 965n 1.8 965.05n 0 970n 0 970.05n 1.8 985n 1.8 985.05n 0 990n 0 990.05n 1.8 995n 1.8
+ 995.05n 0 1000n 0 1000.05n 1.8)
Xd1_a_0 s_a_0 d_a_0 vdrv 0 inv_x1
Xd2_a_0 d_a_0 a_0 vdrv 0 inv_x1
Vs_a_1 s_a_1 0 PWL(0n 0 15n 0 15.05n 1.8 35n 1.8 35.05n 0 50n 0 50.05n 1.8 55n 1.8 55.05n 0 70n 0 70.05n 1.8 90n 1.8
+ 90.05n 0 105n 0 105.05n 1.8 110n 1.8 110.05n 0 120n 0 120.05n 1.8 125n 1.8 125.05n 0 130n 0
+ 130.05n 1.8 135n 1.8 135.05n 0 140n 0 140.05n 1.8 155n 1.8 155.05n 0 160n 0 160.05n 1.8 170n 1.8
+ 170.05n 0 180n 0 180.05n 1.8 190n 1.8 190.05n 0 195n 0 195.05n 1.8 200n 1.8 200.05n 0 210n 0
+ 210.05n 1.8 215n 1.8 215.05n 0 220n 0 220.05n 1.8 225n 1.8 225.05n 0 230n 0 230.05n 1.8 245n 1.8
+ 245.05n 0 255n 0 255.05n 1.8 260n 1.8 260.05n 0 265n 0 265.05n 1.8 275n 1.8 275.05n 0 310n 0
+ 310.05n 1.8 325n 1.8 325.05n 0 330n 0 330.05n 1.8 350n 1.8 350.05n 0 375n 0 375.05n 1.8 380n 1.8
+ 380.05n 0 385n 0 385.05n 1.8 390n 1.8 390.05n 0 405n 0 405.05n 1.8 410n 1.8 410.05n 0 430n 0
+ 430.05n 1.8 435n 1.8 435.05n 0 445n 0 445.05n 1.8 465n 1.8 465.05n 0 485n 0 485.05n 1.8 490n 1.8
+ 490.05n 0 510n 0 510.05n 1.8 525n 1.8 525.05n 0 530n 0 530.05n 1.8 550n 1.8 550.05n 0 555n 0
+ 555.05n 1.8 565n 1.8 565.05n 0 570n 0 570.05n 1.8 575n 1.8 575.05n 0 580n 0 580.05n 1.8 585n 1.8
+ 585.05n 0 590n 0 590.05n 1.8 595n 1.8 595.05n 0 605n 0 605.05n 1.8 615n 1.8 615.05n 0 635n 0
+ 635.05n 1.8 640n 1.8 640.05n 0 645n 0 645.05n 1.8 660n 1.8 660.05n 0 670n 0 670.05n 1.8 680n 1.8
+ 680.05n 0 690n 0 690.05n 1.8 695n 1.8 695.05n 0 705n 0 705.05n 1.8 715n 1.8 715.05n 0 720n 0
+ 720.05n 1.8 725n 1.8 725.05n 0 730n 0 730.05n 1.8 745n 1.8 745.05n 0 750n 0 750.05n 1.8 760n 1.8
+ 760.05n 0 780n 0 780.05n 1.8 810n 1.8 810.05n 0 820n 0 820.05n 1.8 825n 1.8 825.05n 0 830n 0
+ 830.05n 1.8 835n 1.8 835.05n 0 845n 0 845.05n 1.8 855n 1.8 855.05n 0 865n 0 865.05n 1.8 870n 1.8
+ 870.05n 0 890n 0 890.05n 1.8 895n 1.8 895.05n 0 900n 0 900.05n 1.8 905n 1.8 905.05n 0 915n 0
+ 915.05n 1.8 920n 1.8 920.05n 0 950n 0 950.05n 1.8 960n 1.8 960.05n 0 965n 0 965.05n 1.8 1000n 1.8
+ 1000.05n 0)
Xd1_a_1 s_a_1 d_a_1 vdrv 0 inv_x1
Xd2_a_1 d_a_1 a_1 vdrv 0 inv_x1
Vs_a_2 s_a_2 0 PWL(0n 0 5n 0 5.05n 1.8 10n 1.8 10.05n 0 15n 0 15.05n 1.8 40n 1.8 40.05n 0 60n 0 60.05n 1.8 80n 1.8
+ 80.05n 0 85n 0 85.05n 1.8 90n 1.8 90.05n 0 95n 0 95.05n 1.8 105n 1.8 105.05n 0 110n 0 110.05n 1.8
+ 115n 1.8 115.05n 0 120n 0 120.05n 1.8 125n 1.8 125.05n 0 130n 0 130.05n 1.8 140n 1.8 140.05n 0
+ 155n 0 155.05n 1.8 170n 1.8 170.05n 0 175n 0 175.05n 1.8 195n 1.8 195.05n 0 205n 0 205.05n 1.8
+ 215n 1.8 215.05n 0 225n 0 225.05n 1.8 230n 1.8 230.05n 0 250n 0 250.05n 1.8 255n 1.8 255.05n 0
+ 270n 0 270.05n 1.8 275n 1.8 275.05n 0 285n 0 285.05n 1.8 290n 1.8 290.05n 0 295n 0 295.05n 1.8
+ 300n 1.8 300.05n 0 310n 0 310.05n 1.8 320n 1.8 320.05n 0 335n 0 335.05n 1.8 340n 1.8 340.05n 0
+ 345n 0 345.05n 1.8 350n 1.8 350.05n 0 360n 0 360.05n 1.8 380n 1.8 380.05n 0 395n 0 395.05n 1.8
+ 400n 1.8 400.05n 0 415n 0 415.05n 1.8 420n 1.8 420.05n 0 430n 0 430.05n 1.8 445n 1.8 445.05n 0
+ 450n 0 450.05n 1.8 460n 1.8 460.05n 0 475n 0 475.05n 1.8 480n 1.8 480.05n 0 485n 0 485.05n 1.8
+ 500n 1.8 500.05n 0 505n 0 505.05n 1.8 515n 1.8 515.05n 0 525n 0 525.05n 1.8 535n 1.8 535.05n 0
+ 555n 0 555.05n 1.8 560n 1.8 560.05n 0 575n 0 575.05n 1.8 580n 1.8 580.05n 0 585n 0 585.05n 1.8
+ 595n 1.8 595.05n 0 605n 0 605.05n 1.8 610n 1.8 610.05n 0 625n 0 625.05n 1.8 630n 1.8 630.05n 0
+ 635n 0 635.05n 1.8 655n 1.8 655.05n 0 660n 0 660.05n 1.8 665n 1.8 665.05n 0 675n 0 675.05n 1.8
+ 680n 1.8 680.05n 0 695n 0 695.05n 1.8 705n 1.8 705.05n 0 710n 0 710.05n 1.8 715n 1.8 715.05n 0
+ 720n 0 720.05n 1.8 725n 1.8 725.05n 0 730n 0 730.05n 1.8 740n 1.8 740.05n 0 750n 0 750.05n 1.8
+ 755n 1.8 755.05n 0 760n 0 760.05n 1.8 765n 1.8 765.05n 0 770n 0 770.05n 1.8 775n 1.8 775.05n 0
+ 790n 0 790.05n 1.8 800n 1.8 800.05n 0 820n 0 820.05n 1.8 830n 1.8 830.05n 0 835n 0 835.05n 1.8
+ 845n 1.8 845.05n 0 855n 0 855.05n 1.8 865n 1.8 865.05n 0 870n 0 870.05n 1.8 880n 1.8 880.05n 0
+ 890n 0 890.05n 1.8 895n 1.8 895.05n 0 900n 0 900.05n 1.8 925n 1.8 925.05n 0 930n 0 930.05n 1.8
+ 940n 1.8 940.05n 0 945n 0 945.05n 1.8 950n 1.8 950.05n 0 955n 0 955.05n 1.8 985n 1.8 985.05n 0
+ 990n 0 990.05n 1.8 995n 1.8 995.05n 0 1000n 0 1000.05n 1.8)
Xd1_a_2 s_a_2 d_a_2 vdrv 0 inv_x1
Xd2_a_2 d_a_2 a_2 vdrv 0 inv_x1
Vs_a_3 s_a_3 0 PWL(0n 0 10n 0 10.05n 1.8 25n 1.8 25.05n 0 30n 0 30.05n 1.8 40n 1.8 40.05n 0 45n 0 45.05n 1.8 50n 1.8
+ 50.05n 0 60n 0 60.05n 1.8 70n 1.8 70.05n 0 75n 0 75.05n 1.8 85n 1.8 85.05n 0 90n 0 90.05n 1.8
+ 100n 1.8 100.05n 0 110n 0 110.05n 1.8 125n 1.8 125.05n 0 135n 0 135.05n 1.8 145n 1.8 145.05n 0
+ 155n 0 155.05n 1.8 175n 1.8 175.05n 0 190n 0 190.05n 1.8 210n 1.8 210.05n 0 220n 0 220.05n 1.8
+ 245n 1.8 245.05n 0 270n 0 270.05n 1.8 285n 1.8 285.05n 0 290n 0 290.05n 1.8 295n 1.8 295.05n 0
+ 300n 0 300.05n 1.8 320n 1.8 320.05n 0 325n 0 325.05n 1.8 335n 1.8 335.05n 0 370n 0 370.05n 1.8
+ 380n 1.8 380.05n 0 385n 0 385.05n 1.8 390n 1.8 390.05n 0 410n 0 410.05n 1.8 415n 1.8 415.05n 0
+ 420n 0 420.05n 1.8 425n 1.8 425.05n 0 440n 0 440.05n 1.8 450n 1.8 450.05n 0 465n 0 465.05n 1.8
+ 470n 1.8 470.05n 0 475n 0 475.05n 1.8 480n 1.8 480.05n 0 495n 0 495.05n 1.8 515n 1.8 515.05n 0
+ 535n 0 535.05n 1.8 560n 1.8 560.05n 0 580n 0 580.05n 1.8 590n 1.8 590.05n 0 595n 0 595.05n 1.8
+ 610n 1.8 610.05n 0 615n 0 615.05n 1.8 620n 1.8 620.05n 0 625n 0 625.05n 1.8 630n 1.8 630.05n 0
+ 645n 0 645.05n 1.8 650n 1.8 650.05n 0 660n 0 660.05n 1.8 675n 1.8 675.05n 0 690n 0 690.05n 1.8
+ 705n 1.8 705.05n 0 710n 0 710.05n 1.8 730n 1.8 730.05n 0 740n 0 740.05n 1.8 765n 1.8 765.05n 0
+ 775n 0 775.05n 1.8 785n 1.8 785.05n 0 815n 0 815.05n 1.8 825n 1.8 825.05n 0 830n 0 830.05n 1.8
+ 835n 1.8 835.05n 0 845n 0 845.05n 1.8 850n 1.8 850.05n 0 865n 0 865.05n 1.8 870n 1.8 870.05n 0
+ 875n 0 875.05n 1.8 880n 1.8 880.05n 0 885n 0 885.05n 1.8 910n 1.8 910.05n 0 915n 0 915.05n 1.8
+ 925n 1.8 925.05n 0 940n 0 940.05n 1.8 950n 1.8 950.05n 0 955n 0 955.05n 1.8 960n 1.8 960.05n 0
+ 965n 0 965.05n 1.8 970n 1.8 970.05n 0 975n 0 975.05n 1.8 980n 1.8 980.05n 0 985n 0 985.05n 1.8
+ 990n 1.8 990.05n 0)
Xd1_a_3 s_a_3 d_a_3 vdrv 0 inv_x1
Xd2_a_3 d_a_3 a_3 vdrv 0 inv_x1
Vs_b_0 s_b_0 0 PWL(0n 0 10n 0 10.05n 1.8 15n 1.8 15.05n 0 25n 0 25.05n 1.8 30n 1.8 30.05n 0 35n 0 35.05n 1.8 40n 1.8
+ 40.05n 0 45n 0 45.05n 1.8 50n 1.8 50.05n 0 75n 0 75.05n 1.8 85n 1.8 85.05n 0 95n 0 95.05n 1.8
+ 105n 1.8 105.05n 0 115n 0 115.05n 1.8 120n 1.8 120.05n 0 125n 0 125.05n 1.8 130n 1.8 130.05n 0
+ 135n 0 135.05n 1.8 145n 1.8 145.05n 0 150n 0 150.05n 1.8 160n 1.8 160.05n 0 165n 0 165.05n 1.8
+ 170n 1.8 170.05n 0 175n 0 175.05n 1.8 180n 1.8 180.05n 0 185n 0 185.05n 1.8 195n 1.8 195.05n 0
+ 210n 0 210.05n 1.8 220n 1.8 220.05n 0 225n 0 225.05n 1.8 235n 1.8 235.05n 0 245n 0 245.05n 1.8
+ 255n 1.8 255.05n 0 275n 0 275.05n 1.8 290n 1.8 290.05n 0 295n 0 295.05n 1.8 310n 1.8 310.05n 0
+ 315n 0 315.05n 1.8 320n 1.8 320.05n 0 330n 0 330.05n 1.8 335n 1.8 335.05n 0 345n 0 345.05n 1.8
+ 355n 1.8 355.05n 0 360n 0 360.05n 1.8 365n 1.8 365.05n 0 370n 0 370.05n 1.8 380n 1.8 380.05n 0
+ 385n 0 385.05n 1.8 395n 1.8 395.05n 0 400n 0 400.05n 1.8 405n 1.8 405.05n 0 410n 0 410.05n 1.8
+ 420n 1.8 420.05n 0 425n 0 425.05n 1.8 430n 1.8 430.05n 0 435n 0 435.05n 1.8 440n 1.8 440.05n 0
+ 445n 0 445.05n 1.8 460n 1.8 460.05n 0 465n 0 465.05n 1.8 470n 1.8 470.05n 0 475n 0 475.05n 1.8
+ 485n 1.8 485.05n 0 500n 0 500.05n 1.8 520n 1.8 520.05n 0 525n 0 525.05n 1.8 530n 1.8 530.05n 0
+ 545n 0 545.05n 1.8 555n 1.8 555.05n 0 565n 0 565.05n 1.8 570n 1.8 570.05n 0 580n 0 580.05n 1.8
+ 585n 1.8 585.05n 0 595n 0 595.05n 1.8 605n 1.8 605.05n 0 610n 0 610.05n 1.8 615n 1.8 615.05n 0
+ 625n 0 625.05n 1.8 630n 1.8 630.05n 0 635n 0 635.05n 1.8 675n 1.8 675.05n 0 685n 0 685.05n 1.8
+ 690n 1.8 690.05n 0 710n 0 710.05n 1.8 715n 1.8 715.05n 0 720n 0 720.05n 1.8 740n 1.8 740.05n 0
+ 755n 0 755.05n 1.8 765n 1.8 765.05n 0 775n 0 775.05n 1.8 790n 1.8 790.05n 0 815n 0 815.05n 1.8
+ 830n 1.8 830.05n 0 835n 0 835.05n 1.8 840n 1.8 840.05n 0 845n 0 845.05n 1.8 855n 1.8 855.05n 0
+ 860n 0 860.05n 1.8 865n 1.8 865.05n 0 870n 0 870.05n 1.8 885n 1.8 885.05n 0 890n 0 890.05n 1.8
+ 895n 1.8 895.05n 0 925n 0 925.05n 1.8 930n 1.8 930.05n 0 945n 0 945.05n 1.8 955n 1.8 955.05n 0
+ 965n 0 965.05n 1.8 970n 1.8 970.05n 0 975n 0 975.05n 1.8 985n 1.8 985.05n 0 990n 0 990.05n 1.8
+ 1000n 1.8 1000.05n 0)
Xd1_b_0 s_b_0 d_b_0 vdrv 0 inv_x1
Xd2_b_0 d_b_0 b_0 vdrv 0 inv_x1
Vs_b_1 s_b_1 0 PWL(0n 0 5n 0 5.05n 1.8 20n 1.8 20.05n 0 25n 0 25.05n 1.8 30n 1.8 30.05n 0 40n 0 40.05n 1.8 55n 1.8
+ 55.05n 0 60n 0 60.05n 1.8 65n 1.8 65.05n 0 70n 0 70.05n 1.8 90n 1.8 90.05n 0 95n 0 95.05n 1.8
+ 100n 1.8 100.05n 0 105n 0 105.05n 1.8 115n 1.8 115.05n 0 125n 0 125.05n 1.8 130n 1.8 130.05n 0
+ 140n 0 140.05n 1.8 150n 1.8 150.05n 0 155n 0 155.05n 1.8 160n 1.8 160.05n 0 185n 0 185.05n 1.8
+ 200n 1.8 200.05n 0 215n 0 215.05n 1.8 230n 1.8 230.05n 0 240n 0 240.05n 1.8 250n 1.8 250.05n 0
+ 260n 0 260.05n 1.8 265n 1.8 265.05n 0 275n 0 275.05n 1.8 295n 1.8 295.05n 0 310n 0 310.05n 1.8
+ 320n 1.8 320.05n 0 350n 0 350.05n 1.8 355n 1.8 355.05n 0 365n 0 365.05n 1.8 380n 1.8 380.05n 0
+ 395n 0 395.05n 1.8 400n 1.8 400.05n 0 405n 0 405.05n 1.8 410n 1.8 410.05n 0 430n 0 430.05n 1.8
+ 435n 1.8 435.05n 0 440n 0 440.05n 1.8 450n 1.8 450.05n 0 455n 0 455.05n 1.8 460n 1.8 460.05n 0
+ 465n 0 465.05n 1.8 475n 1.8 475.05n 0 485n 0 485.05n 1.8 515n 1.8 515.05n 0 540n 0 540.05n 1.8
+ 555n 1.8 555.05n 0 560n 0 560.05n 1.8 565n 1.8 565.05n 0 580n 0 580.05n 1.8 605n 1.8 605.05n 0
+ 620n 0 620.05n 1.8 635n 1.8 635.05n 0 640n 0 640.05n 1.8 645n 1.8 645.05n 0 665n 0 665.05n 1.8
+ 680n 1.8 680.05n 0 690n 0 690.05n 1.8 725n 1.8 725.05n 0 735n 0 735.05n 1.8 760n 1.8 760.05n 0
+ 765n 0 765.05n 1.8 790n 1.8 790.05n 0 805n 0 805.05n 1.8 810n 1.8 810.05n 0 815n 0 815.05n 1.8
+ 835n 1.8 835.05n 0 855n 0 855.05n 1.8 860n 1.8 860.05n 0 865n 0 865.05n 1.8 870n 1.8 870.05n 0
+ 880n 0 880.05n 1.8 890n 1.8 890.05n 0 895n 0 895.05n 1.8 900n 1.8 900.05n 0 905n 0 905.05n 1.8
+ 910n 1.8 910.05n 0 925n 0 925.05n 1.8 930n 1.8 930.05n 0 950n 0 950.05n 1.8 955n 1.8 955.05n 0
+ 960n 0 960.05n 1.8 980n 1.8 980.05n 0 995n 0 995.05n 1.8)
Xd1_b_1 s_b_1 d_b_1 vdrv 0 inv_x1
Xd2_b_1 d_b_1 b_1 vdrv 0 inv_x1
Vs_b_2 s_b_2 0 PWL(0n 0 15n 0 15.05n 1.8 25n 1.8 25.05n 0 35n 0 35.05n 1.8 50n 1.8 50.05n 0 60n 0 60.05n 1.8 65n 1.8
+ 65.05n 0 70n 0 70.05n 1.8 90n 1.8 90.05n 0 110n 0 110.05n 1.8 115n 1.8 115.05n 0 120n 0 120.05n 1.8
+ 140n 1.8 140.05n 0 145n 0 145.05n 1.8 155n 1.8 155.05n 0 170n 0 170.05n 1.8 180n 1.8 180.05n 0
+ 185n 0 185.05n 1.8 190n 1.8 190.05n 0 195n 0 195.05n 1.8 200n 1.8 200.05n 0 205n 0 205.05n 1.8
+ 235n 1.8 235.05n 0 240n 0 240.05n 1.8 255n 1.8 255.05n 0 275n 0 275.05n 1.8 280n 1.8 280.05n 0
+ 295n 0 295.05n 1.8 305n 1.8 305.05n 0 315n 0 315.05n 1.8 320n 1.8 320.05n 0 325n 0 325.05n 1.8
+ 335n 1.8 335.05n 0 345n 0 345.05n 1.8 360n 1.8 360.05n 0 365n 0 365.05n 1.8 390n 1.8 390.05n 0
+ 395n 0 395.05n 1.8 400n 1.8 400.05n 0 415n 0 415.05n 1.8 425n 1.8 425.05n 0 430n 0 430.05n 1.8
+ 435n 1.8 435.05n 0 440n 0 440.05n 1.8 445n 1.8 445.05n 0 450n 0 450.05n 1.8 470n 1.8 470.05n 0
+ 480n 0 480.05n 1.8 485n 1.8 485.05n 0 495n 0 495.05n 1.8 500n 1.8 500.05n 0 510n 0 510.05n 1.8
+ 515n 1.8 515.05n 0 520n 0 520.05n 1.8 530n 1.8 530.05n 0 550n 0 550.05n 1.8 560n 1.8 560.05n 0
+ 565n 0 565.05n 1.8 580n 1.8 580.05n 0 630n 0 630.05n 1.8 640n 1.8 640.05n 0 645n 0 645.05n 1.8
+ 660n 1.8 660.05n 0 665n 0 665.05n 1.8 670n 1.8 670.05n 0 690n 0 690.05n 1.8 695n 1.8 695.05n 0
+ 715n 0 715.05n 1.8 720n 1.8 720.05n 0 725n 0 725.05n 1.8 730n 1.8 730.05n 0 735n 0 735.05n 1.8
+ 740n 1.8 740.05n 0 755n 0 755.05n 1.8 760n 1.8 760.05n 0 775n 0 775.05n 1.8 780n 1.8 780.05n 0
+ 785n 0 785.05n 1.8 790n 1.8 790.05n 0 795n 0 795.05n 1.8 800n 1.8 800.05n 0 820n 0 820.05n 1.8
+ 825n 1.8 825.05n 0 835n 0 835.05n 1.8 845n 1.8 845.05n 0 855n 0 855.05n 1.8 860n 1.8 860.05n 0
+ 865n 0 865.05n 1.8 870n 1.8 870.05n 0 875n 0 875.05n 1.8 885n 1.8 885.05n 0 890n 0 890.05n 1.8
+ 900n 1.8 900.05n 0 930n 0 930.05n 1.8 935n 1.8 935.05n 0 940n 0 940.05n 1.8 955n 1.8 955.05n 0
+ 965n 0 965.05n 1.8 970n 1.8 970.05n 0 975n 0 975.05n 1.8 985n 1.8 985.05n 0 1000n 0 1000.05n 1.8)
Xd1_b_2 s_b_2 d_b_2 vdrv 0 inv_x1
Xd2_b_2 d_b_2 b_2 vdrv 0 inv_x1
Vs_b_3 s_b_3 0 PWL(0n 0 15n 0 15.05n 1.8 25n 1.8 25.05n 0 35n 0 35.05n 1.8 45n 1.8 45.05n 0 50n 0 50.05n 1.8 55n 1.8
+ 55.05n 0 70n 0 70.05n 1.8 75n 1.8 75.05n 0 85n 0 85.05n 1.8 90n 1.8 90.05n 0 100n 0 100.05n 1.8
+ 110n 1.8 110.05n 0 115n 0 115.05n 1.8 135n 1.8 135.05n 0 140n 0 140.05n 1.8 150n 1.8 150.05n 0
+ 155n 0 155.05n 1.8 160n 1.8 160.05n 0 170n 0 170.05n 1.8 175n 1.8 175.05n 0 190n 0 190.05n 1.8
+ 200n 1.8 200.05n 0 210n 0 210.05n 1.8 220n 1.8 220.05n 0 225n 0 225.05n 1.8 235n 1.8 235.05n 0
+ 240n 0 240.05n 1.8 245n 1.8 245.05n 0 255n 0 255.05n 1.8 260n 1.8 260.05n 0 285n 0 285.05n 1.8
+ 290n 1.8 290.05n 0 305n 0 305.05n 1.8 320n 1.8 320.05n 0 325n 0 325.05n 1.8 350n 1.8 350.05n 0
+ 355n 0 355.05n 1.8 360n 1.8 360.05n 0 365n 0 365.05n 1.8 370n 1.8 370.05n 0 380n 0 380.05n 1.8
+ 395n 1.8 395.05n 0 400n 0 400.05n 1.8 405n 1.8 405.05n 0 410n 0 410.05n 1.8 420n 1.8 420.05n 0
+ 430n 0 430.05n 1.8 435n 1.8 435.05n 0 450n 0 450.05n 1.8 480n 1.8 480.05n 0 485n 0 485.05n 1.8
+ 495n 1.8 495.05n 0 505n 0 505.05n 1.8 510n 1.8 510.05n 0 530n 0 530.05n 1.8 545n 1.8 545.05n 0
+ 560n 0 560.05n 1.8 575n 1.8 575.05n 0 595n 0 595.05n 1.8 600n 1.8 600.05n 0 605n 0 605.05n 1.8
+ 610n 1.8 610.05n 0 635n 0 635.05n 1.8 640n 1.8 640.05n 0 655n 0 655.05n 1.8 670n 1.8 670.05n 0
+ 675n 0 675.05n 1.8 680n 1.8 680.05n 0 685n 0 685.05n 1.8 700n 1.8 700.05n 0 705n 0 705.05n 1.8
+ 710n 1.8 710.05n 0 720n 0 720.05n 1.8 725n 1.8 725.05n 0 730n 0 730.05n 1.8 735n 1.8 735.05n 0
+ 760n 0 760.05n 1.8 775n 1.8 775.05n 0 795n 0 795.05n 1.8 805n 1.8 805.05n 0 815n 0 815.05n 1.8
+ 825n 1.8 825.05n 0 845n 0 845.05n 1.8 855n 1.8 855.05n 0 870n 0 870.05n 1.8 875n 1.8 875.05n 0
+ 890n 0 890.05n 1.8 900n 1.8 900.05n 0 905n 0 905.05n 1.8 915n 1.8 915.05n 0 925n 0 925.05n 1.8
+ 930n 1.8 930.05n 0 935n 0 935.05n 1.8 945n 1.8 945.05n 0 960n 0 960.05n 1.8 965n 1.8 965.05n 0
+ 970n 0 970.05n 1.8 990n 1.8 990.05n 0 995n 0 995.05n 1.8 1000n 1.8 1000.05n 0)
Xd1_b_3 s_b_3 d_b_3 vdrv 0 inv_x1
Xd2_b_3 d_b_3 b_3 vdrv 0 inv_x1
Vs_s_0 s_s_0 0 PWL(0n 1.8 5n 1.8 5.05n 0 130n 0 130.05n 1.8 255n 1.8 255.05n 0 380n 0 380.05n 1.8 505n 1.8 505.05n 0
+ 630n 0 630.05n 1.8 755n 1.8 755.05n 0 880n 0 880.05n 1.8)
Xd1_s_0 s_s_0 d_s_0 vdrv 0 inv_x1
Xd2_s_0 d_s_0 s_0 vdrv 0 inv_x1
Vs_s_1 s_s_1 0 PWL(0n 0 255n 0 255.05n 1.8 505n 1.8 505.05n 0 755n 0 755.05n 1.8)
Xd1_s_1 s_s_1 d_s_1 vdrv 0 inv_x1
Xd2_s_1 d_s_1 s_1 vdrv 0 inv_x1
Vs_s_2 s_s_2 0 PWL(0n 0 505n 0 505.05n 1.8)
Xd1_s_2 s_s_2 d_s_2 vdrv 0 inv_x1
Xd2_s_2 d_s_2 s_2 vdrv 0 inv_x1
Xalu a_0 a_1 a_2 a_3 b_0 b_1 b_2 b_3 s_0 s_1 s_2 y_0 y_1 y_2 y_3 c v z n vdd_dut 0 alu4_fb
Xl_y_0_0 y_0 ld_y_0_0 vld 0 inv_x1
Xl_y_0_1 y_0 ld_y_0_1 vld 0 inv_x1
Xl_y_0_2 y_0 ld_y_0_2 vld 0 inv_x1
Xl_y_0_3 y_0 ld_y_0_3 vld 0 inv_x1
Xl_y_1_0 y_1 ld_y_1_0 vld 0 inv_x1
Xl_y_1_1 y_1 ld_y_1_1 vld 0 inv_x1
Xl_y_1_2 y_1 ld_y_1_2 vld 0 inv_x1
Xl_y_1_3 y_1 ld_y_1_3 vld 0 inv_x1
Xl_y_2_0 y_2 ld_y_2_0 vld 0 inv_x1
Xl_y_2_1 y_2 ld_y_2_1 vld 0 inv_x1
Xl_y_2_2 y_2 ld_y_2_2 vld 0 inv_x1
Xl_y_2_3 y_2 ld_y_2_3 vld 0 inv_x1
Xl_y_3_0 y_3 ld_y_3_0 vld 0 inv_x1
Xl_y_3_1 y_3 ld_y_3_1 vld 0 inv_x1
Xl_y_3_2 y_3 ld_y_3_2 vld 0 inv_x1
Xl_y_3_3 y_3 ld_y_3_3 vld 0 inv_x1
Xl_c_0 c ld_c_0 vld 0 inv_x1
Xl_c_1 c ld_c_1 vld 0 inv_x1
Xl_c_2 c ld_c_2 vld 0 inv_x1
Xl_c_3 c ld_c_3 vld 0 inv_x1
Xl_v_0 v ld_v_0 vld 0 inv_x1
Xl_v_1 v ld_v_1 vld 0 inv_x1
Xl_v_2 v ld_v_2 vld 0 inv_x1
Xl_v_3 v ld_v_3 vld 0 inv_x1
Xl_z_0 z ld_z_0 vld 0 inv_x1
Xl_z_1 z ld_z_1 vld 0 inv_x1
Xl_z_2 z ld_z_2 vld 0 inv_x1
Xl_z_3 z ld_z_3 vld 0 inv_x1
Xl_n_0 n ld_n_0 vld 0 inv_x1
Xl_n_1 n ld_n_1 vld 0 inv_x1
Xl_n_2 n ld_n_2 vld 0 inv_x1
Xl_n_3 n ld_n_3 vld 0 inv_x1
* decimal words for plotting and measuring: operands, operation, result, flags (8c+4v+2z+n)
Baw aw 0 V=(1*V(a_0)+2*V(a_1)+4*V(a_2)+8*V(a_3))/1.8
Bbw bw 0 V=(1*V(b_0)+2*V(b_1)+4*V(b_2)+8*V(b_3))/1.8
Bsw sw 0 V=(V(s_0)+2*V(s_1)+4*V(s_2))/1.8
Byw yw 0 V=(1*V(y_0)+2*V(y_1)+4*V(y_2)+8*V(y_3))/1.8
Bfw fw 0 V=(8*V(c)+4*V(v)+2*V(z)+V(n))/1.8
Vwin win 0 PWL(0n 0 9.999n 0 10n 1 129.999n 1 130n 0 134.999n 0 135n 1 254.999n 1 255n 0 259.999n 0 260n 1
+ 379.999n 1 380n 0 384.999n 0 385n 1 504.999n 1 505n 0 509.999n 0 510n 1 629.999n 1 630n 0 634.999n 0
+ 635n 1 754.999n 1 755n 0 759.999n 0 760n 1 879.999n 1 880n 0 884.999n 0 885n 1)
Befj efj 0 V=-I(Vdut)*V(win)*9375000
.save V(aw) V(bw) V(sw) V(yw) V(fw) V(a_0) V(a_1) V(a_2) V(a_3) V(b_0) V(b_1) V(b_2) V(b_3) V(s_0)
+ V(s_1) V(s_2) V(y_0) V(y_1) V(y_2) V(y_3) V(c) V(v) V(z) V(n) V(win) V(efj) I(Vdut)
.tran 10p 1005n 5n 20p
.meas tran e_op_fJ AVG V(efj)
.end
