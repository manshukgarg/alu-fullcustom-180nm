* Transistor netlists of the project cell library pl018, devices as laid out
* (generated by step5_library/gen_library.py; junctions estimated for a 0.5 um diffusion)
.subckt pl_inv A Y vdd gnd
M0 gnd A Y gnd nfet w=0.8u l=0.2u ad=0.4p as=0.4p pd=2.6u ps=2.6u
M1 Y A gnd gnd nfet w=0.7u l=0.2u ad=0.35p as=0.35p pd=2.4u ps=2.4u
M2 vdd A Y vdd pfet w=1.9u l=0.2u ad=0.95p as=0.95p pd=4.8u ps=4.8u
M3 Y A vdd vdd pfet w=1.9u l=0.2u ad=0.95p as=0.95p pd=4.8u ps=4.8u
.ends pl_inv
.subckt pl_buf A Y vdd gnd
M0 Yn A gnd gnd nfet w=1u l=0.2u ad=0.5p as=0.5p pd=3u ps=3u
M1 Yn A vdd vdd pfet w=2.5u l=0.2u ad=1.25p as=1.25p pd=6u ps=6u
M2 gnd Yn Y gnd nfet w=1u l=0.2u ad=0.5p as=0.5p pd=3u ps=3u
M3 Y Yn gnd gnd nfet w=1u l=0.2u ad=0.5p as=0.5p pd=3u ps=3u
M4 vdd Yn Y vdd pfet w=2.5u l=0.2u ad=1.25p as=1.25p pd=6u ps=6u
M5 Y Yn vdd vdd pfet w=2.5u l=0.2u ad=1.25p as=1.25p pd=6u ps=6u
.ends pl_buf
.subckt pl_nand2 A B Y vdd gnd
M0 gnd B x gnd nfet w=2u l=0.2u ad=1p as=1p pd=5u ps=5u
M1 vdd B Y vdd pfet w=2.5u l=0.2u ad=1.25p as=1.25p pd=6u ps=6u
M2 x A Y gnd nfet w=2u l=0.2u ad=1p as=1p pd=5u ps=5u
M3 Y A vdd vdd pfet w=2.5u l=0.2u ad=1.25p as=1.25p pd=6u ps=6u
.ends pl_nand2
.subckt pl_nor2 A B Y vdd gnd
M0 gnd A Y gnd nfet w=0.5u l=0.2u ad=0.25p as=0.25p pd=2u ps=2u
M1 Y A gnd gnd nfet w=0.5u l=0.2u ad=0.25p as=0.25p pd=2u ps=2u
M2 Y A x_1 vdd pfet w=2u l=0.2u ad=1p as=1p pd=5u ps=5u
M3 x_2 A Y vdd pfet w=2u l=0.2u ad=1p as=1p pd=5u ps=5u
M4 Y B gnd gnd nfet w=0.5u l=0.2u ad=0.25p as=0.25p pd=2u ps=2u
M5 gnd B Y gnd nfet w=0.5u l=0.2u ad=0.25p as=0.25p pd=2u ps=2u
M6 x_1 B vdd vdd pfet w=2u l=0.2u ad=1p as=1p pd=5u ps=5u
M7 vdd B x_2 vdd pfet w=2u l=0.2u ad=1p as=1p pd=5u ps=5u
.ends pl_nor2
.subckt pl_and2 A B Y vdd gnd
M0 Yn A x gnd nfet w=2u l=0.2u ad=1p as=1p pd=5u ps=5u
M1 vdd A Yn vdd pfet w=2.5u l=0.2u ad=1.25p as=1.25p pd=6u ps=6u
M2 x B gnd gnd nfet w=2u l=0.2u ad=1p as=1p pd=5u ps=5u
M3 Yn B vdd vdd pfet w=2.5u l=0.2u ad=1.25p as=1.25p pd=6u ps=6u
M4 gnd Yn Y gnd nfet w=1u l=0.2u ad=0.5p as=0.5p pd=3u ps=3u
M5 vdd Yn Y vdd pfet w=2.5u l=0.2u ad=1.25p as=1.25p pd=6u ps=6u
.ends pl_and2
.subckt pl_or2 A B Y vdd gnd
M0 gnd A Yn gnd nfet w=0.8u l=0.2u ad=0.4p as=0.4p pd=2.6u ps=2.6u
M1 Yn A x vdd pfet w=3.2u l=0.2u ad=1.6p as=1.6p pd=7.4u ps=7.4u
M2 Yn B gnd gnd nfet w=0.8u l=0.2u ad=0.4p as=0.4p pd=2.6u ps=2.6u
M3 x B vdd vdd pfet w=3.2u l=0.2u ad=1.6p as=1.6p pd=7.4u ps=7.4u
M4 gnd Yn Y gnd nfet w=0.8u l=0.2u ad=0.4p as=0.4p pd=2.6u ps=2.6u
M5 vdd Yn Y vdd pfet w=1.6u l=0.2u ad=0.8p as=0.8p pd=4.2u ps=4.2u
.ends pl_or2
.subckt pl_xor2 A B Y vdd gnd
M0 A B Xn gnd nfet w=0.5u l=0.2u ad=0.25p as=0.25p pd=2u ps=2u
M1 A Bn Xn vdd pfet w=1u l=0.2u ad=0.5p as=0.5p pd=3u ps=3u
M2 Xn Bn An gnd nfet w=0.5u l=0.2u ad=0.25p as=0.25p pd=2u ps=2u
M3 Xn B An vdd pfet w=1u l=0.2u ad=0.5p as=0.5p pd=3u ps=3u
M4 An A gnd gnd nfet w=0.5u l=0.2u ad=0.25p as=0.25p pd=2u ps=2u
M5 An A vdd vdd pfet w=1u l=0.2u ad=0.5p as=0.5p pd=3u ps=3u
M6 gnd B Bn gnd nfet w=0.5u l=0.2u ad=0.25p as=0.25p pd=2u ps=2u
M7 vdd B Bn vdd pfet w=1u l=0.2u ad=0.5p as=0.5p pd=3u ps=3u
M8 Y Xn gnd gnd nfet w=1u l=0.2u ad=0.5p as=0.5p pd=3u ps=3u
M9 Y Xn vdd vdd pfet w=2u l=0.2u ad=1p as=1p pd=5u ps=5u
.ends pl_xor2
.subckt pl_mux2 A B S Y vdd gnd
M0 Sn S gnd gnd nfet w=0.5u l=0.2u ad=0.25p as=0.25p pd=2u ps=2u
M1 Sn S vdd vdd pfet w=1u l=0.2u ad=0.5p as=0.5p pd=3u ps=3u
M2 gnd M Mn gnd nfet w=0.5u l=0.2u ad=0.25p as=0.25p pd=2u ps=2u
M3 vdd M Mn vdd pfet w=1u l=0.2u ad=0.5p as=0.5p pd=3u ps=3u
M4 A Sn M gnd nfet w=0.5u l=0.2u ad=0.25p as=0.25p pd=2u ps=2u
M5 A S M vdd pfet w=1u l=0.2u ad=0.5p as=0.5p pd=3u ps=3u
M6 M S B gnd nfet w=0.5u l=0.2u ad=0.25p as=0.25p pd=2u ps=2u
M7 M Sn B vdd pfet w=1u l=0.2u ad=0.5p as=0.5p pd=3u ps=3u
M8 Y Mn gnd gnd nfet w=1u l=0.2u ad=0.5p as=0.5p pd=3u ps=3u
M9 Y Mn vdd vdd pfet w=2u l=0.2u ad=1p as=1p pd=5u ps=5u
.ends pl_mux2
.subckt pl_mux2i A B S Y vdd gnd
M0 Sn S gnd gnd nfet w=0.4u l=0.2u ad=0.2p as=0.2p pd=1.8u ps=1.8u
M1 Sn S vdd vdd pfet w=0.8u l=0.2u ad=0.4p as=0.4p pd=2.6u ps=2.6u
M2 gnd M Y gnd nfet w=0.6u l=0.2u ad=0.3p as=0.3p pd=2.2u ps=2.2u
M3 vdd M Y vdd pfet w=1.5u l=0.2u ad=0.75p as=0.75p pd=4u ps=4u
M4 A Sn M gnd nfet w=0.4u l=0.2u ad=0.2p as=0.2p pd=1.8u ps=1.8u
M5 A S M vdd pfet w=0.8u l=0.2u ad=0.4p as=0.4p pd=2.6u ps=2.6u
M6 M S B gnd nfet w=0.4u l=0.2u ad=0.2p as=0.2p pd=1.8u ps=1.8u
M7 M Sn B vdd pfet w=0.8u l=0.2u ad=0.4p as=0.4p pd=2.6u ps=2.6u
.ends pl_mux2i
.subckt pl_fa A B C S CO vdd gnd
M0 A Bn P gnd nfet w=0.4u l=0.2u ad=0.2p as=0.2p pd=1.8u ps=1.8u
M1 A B P vdd pfet w=0.6u l=0.2u ad=0.3p as=0.3p pd=2.2u ps=2.2u
M2 P B An gnd nfet w=0.4u l=0.2u ad=0.2p as=0.2p pd=1.8u ps=1.8u
M3 P Bn An vdd pfet w=0.6u l=0.2u ad=0.3p as=0.3p pd=2.2u ps=2.2u
M4 Bn B gnd gnd nfet w=0.4u l=0.2u ad=0.2p as=0.2p pd=1.8u ps=1.8u
M5 Bn B vdd vdd pfet w=0.6u l=0.2u ad=0.3p as=0.3p pd=2.2u ps=2.2u
M6 gnd A An gnd nfet w=0.4u l=0.2u ad=0.2p as=0.2p pd=1.8u ps=1.8u
M7 vdd A An vdd pfet w=0.6u l=0.2u ad=0.3p as=0.3p pd=2.2u ps=2.2u
M8 An Pn COx gnd nfet w=0.4u l=0.2u ad=0.2p as=0.2p pd=1.8u ps=1.8u
M9 An P COx vdd pfet w=0.6u l=0.2u ad=0.3p as=0.3p pd=2.2u ps=2.2u
M10 COx P Cn gnd nfet w=0.4u l=0.2u ad=0.2p as=0.2p pd=1.8u ps=1.8u
M11 COx Pn Cn vdd pfet w=0.6u l=0.2u ad=0.3p as=0.3p pd=2.2u ps=2.2u
M12 Cn Pn Sx gnd nfet w=0.4u l=0.2u ad=0.2p as=0.2p pd=1.8u ps=1.8u
M13 Cn P Sx vdd pfet w=0.6u l=0.2u ad=0.3p as=0.3p pd=2.2u ps=2.2u
M14 Sx P C gnd nfet w=0.4u l=0.2u ad=0.2p as=0.2p pd=1.8u ps=1.8u
M15 Sx Pn C vdd pfet w=0.6u l=0.2u ad=0.3p as=0.3p pd=2.2u ps=2.2u
M16 Cn C gnd gnd nfet w=0.4u l=0.2u ad=0.2p as=0.2p pd=1.8u ps=1.8u
M17 Cn C vdd vdd pfet w=0.6u l=0.2u ad=0.3p as=0.3p pd=2.2u ps=2.2u
M18 gnd P Pn gnd nfet w=0.4u l=0.2u ad=0.2p as=0.2p pd=1.8u ps=1.8u
M19 vdd P Pn vdd pfet w=0.6u l=0.2u ad=0.3p as=0.3p pd=2.2u ps=2.2u
M20 S Sx gnd gnd nfet w=0.8u l=0.2u ad=0.4p as=0.4p pd=2.6u ps=2.6u
M21 S Sx vdd vdd pfet w=1.2u l=0.2u ad=0.6p as=0.6p pd=3.4u ps=3.4u
M22 gnd COx CO gnd nfet w=0.8u l=0.2u ad=0.4p as=0.4p pd=2.6u ps=2.6u
M23 vdd COx CO vdd pfet w=1.2u l=0.2u ad=0.6p as=0.6p pd=3.4u ps=3.4u
.ends pl_fa
.subckt pl_fill vdd gnd
.ends pl_fill
