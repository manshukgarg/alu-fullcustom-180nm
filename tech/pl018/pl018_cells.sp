* Transistor netlists of the project cell library pl018, devices as laid out
* (generated by step5_library/gen_library.py; junctions estimated for a 0.5 um diffusion)
.subckt pl_inv A Y vdd gnd
M0 gnd A Y gnd nfet w=0.8u l=0.2u ad=0.4p as=0.4p pd=2.6u ps=2.6u
M1 vdd A Y vdd pfet w=2u l=0.2u ad=1p as=1p pd=5u ps=5u
.ends pl_inv
.subckt pl_buf A Y vdd gnd
M0 Yn A gnd gnd nfet w=1u l=0.2u ad=0.5p as=0.5p pd=3u ps=3u
M1 Yn A vdd vdd pfet w=2.5u l=0.2u ad=1.25p as=1.25p pd=6u ps=6u
M2 gnd Yn Y gnd nfet w=1u l=0.2u ad=0.5p as=0.5p pd=3u ps=3u
M3 Y Yn gnd gnd nfet w=1u l=0.2u ad=0.5p as=0.5p pd=3u ps=3u
M4 vdd Yn Y vdd pfet w=2.5u l=0.2u ad=1.25p as=1.25p pd=6u ps=6u
M5 Y Yn vdd vdd pfet w=2.5u l=0.2u ad=1.25p as=1.25p pd=6u ps=6u
.ends pl_buf
.subckt pl_nand2 A B Y vdd gnd
M0 gnd B x gnd nfet w=1.2u l=0.2u ad=0.6p as=0.6p pd=3.4u ps=3.4u
M1 vdd B Y vdd pfet w=1.8u l=0.2u ad=0.9p as=0.9p pd=4.6u ps=4.6u
M2 x A Y gnd nfet w=1.2u l=0.2u ad=0.6p as=0.6p pd=3.4u ps=3.4u
M3 Y A vdd vdd pfet w=1.8u l=0.2u ad=0.9p as=0.9p pd=4.6u ps=4.6u
.ends pl_nand2
.subckt pl_nor2 A B Y vdd gnd
M0 gnd A Y gnd nfet w=0.6u l=0.2u ad=0.3p as=0.3p pd=2.2u ps=2.2u
M1 Y A x vdd pfet w=3u l=0.2u ad=1.5p as=1.5p pd=7u ps=7u
M2 Y B gnd gnd nfet w=0.6u l=0.2u ad=0.3p as=0.3p pd=2.2u ps=2.2u
M3 x B vdd vdd pfet w=3u l=0.2u ad=1.5p as=1.5p pd=7u ps=7u
.ends pl_nor2
.subckt pl_and2 A B Y vdd gnd
M0 Yn A x gnd nfet w=1.2u l=0.2u ad=0.6p as=0.6p pd=3.4u ps=3.4u
M1 vdd A Yn vdd pfet w=1.5u l=0.2u ad=0.75p as=0.75p pd=4u ps=4u
M2 x B gnd gnd nfet w=1.2u l=0.2u ad=0.6p as=0.6p pd=3.4u ps=3.4u
M3 Yn B vdd vdd pfet w=1.5u l=0.2u ad=0.75p as=0.75p pd=4u ps=4u
M4 gnd Yn Y gnd nfet w=0.6u l=0.2u ad=0.3p as=0.3p pd=2.2u ps=2.2u
M5 vdd Yn Y vdd pfet w=1.5u l=0.2u ad=0.75p as=0.75p pd=4u ps=4u
.ends pl_and2
.subckt pl_or2 A B Y vdd gnd
M0 gnd A Yn gnd nfet w=0.8u l=0.2u ad=0.4p as=0.4p pd=2.6u ps=2.6u
M1 Yn A x vdd pfet w=2.4u l=0.2u ad=1.2p as=1.2p pd=5.8u ps=5.8u
M2 Yn B gnd gnd nfet w=0.8u l=0.2u ad=0.4p as=0.4p pd=2.6u ps=2.6u
M3 x B vdd vdd pfet w=2.4u l=0.2u ad=1.2p as=1.2p pd=5.8u ps=5.8u
M4 gnd Yn Y gnd nfet w=0.8u l=0.2u ad=0.4p as=0.4p pd=2.6u ps=2.6u
M5 vdd Yn Y vdd pfet w=1.2u l=0.2u ad=0.6p as=0.6p pd=3.4u ps=3.4u
.ends pl_or2
.subckt pl_xor2 A B Y vdd gnd
M0 A B Xn gnd nfet w=0.4u l=0.2u ad=0.2p as=0.2p pd=1.8u ps=1.8u
M1 A Bn Xn vdd pfet w=0.6u l=0.2u ad=0.3p as=0.3p pd=2.2u ps=2.2u
M2 Xn Bn An gnd nfet w=0.4u l=0.2u ad=0.2p as=0.2p pd=1.8u ps=1.8u
M3 Xn B An vdd pfet w=0.6u l=0.2u ad=0.3p as=0.3p pd=2.2u ps=2.2u
M4 An A gnd gnd nfet w=0.4u l=0.2u ad=0.2p as=0.2p pd=1.8u ps=1.8u
M5 An A vdd vdd pfet w=0.6u l=0.2u ad=0.3p as=0.3p pd=2.2u ps=2.2u
M6 gnd B Bn gnd nfet w=0.4u l=0.2u ad=0.2p as=0.2p pd=1.8u ps=1.8u
M7 vdd B Bn vdd pfet w=0.6u l=0.2u ad=0.3p as=0.3p pd=2.2u ps=2.2u
M8 Y Xn gnd gnd nfet w=0.8u l=0.2u ad=0.4p as=0.4p pd=2.6u ps=2.6u
M9 Y Xn vdd vdd pfet w=1.2u l=0.2u ad=0.6p as=0.6p pd=3.4u ps=3.4u
.ends pl_xor2
.subckt pl_mux2 A B S Y vdd gnd
M0 Sn S gnd gnd nfet w=0.4u l=0.2u ad=0.2p as=0.2p pd=1.8u ps=1.8u
M1 Sn S vdd vdd pfet w=0.6u l=0.2u ad=0.3p as=0.3p pd=2.2u ps=2.2u
M2 gnd M Mn gnd nfet w=0.4u l=0.2u ad=0.2p as=0.2p pd=1.8u ps=1.8u
M3 vdd M Mn vdd pfet w=0.6u l=0.2u ad=0.3p as=0.3p pd=2.2u ps=2.2u
M4 A Sn M gnd nfet w=0.4u l=0.2u ad=0.2p as=0.2p pd=1.8u ps=1.8u
M5 A S M vdd pfet w=0.6u l=0.2u ad=0.3p as=0.3p pd=2.2u ps=2.2u
M6 M S B gnd nfet w=0.4u l=0.2u ad=0.2p as=0.2p pd=1.8u ps=1.8u
M7 M Sn B vdd pfet w=0.6u l=0.2u ad=0.3p as=0.3p pd=2.2u ps=2.2u
M8 Y Mn gnd gnd nfet w=0.6u l=0.2u ad=0.3p as=0.3p pd=2.2u ps=2.2u
M9 Y Mn vdd vdd pfet w=1.2u l=0.2u ad=0.6p as=0.6p pd=3.4u ps=3.4u
.ends pl_mux2
.subckt pl_mux2i A B S Y vdd gnd
M0 Sn S gnd gnd nfet w=0.4u l=0.2u ad=0.2p as=0.2p pd=1.8u ps=1.8u
M1 Sn S vdd vdd pfet w=0.8u l=0.2u ad=0.4p as=0.4p pd=2.6u ps=2.6u
M2 gnd M Y gnd nfet w=0.6u l=0.2u ad=0.3p as=0.3p pd=2.2u ps=2.2u
M3 vdd M Y vdd pfet w=1.5u l=0.2u ad=0.75p as=0.75p pd=4u ps=4u
M4 A Sn M gnd nfet w=0.4u l=0.2u ad=0.2p as=0.2p pd=1.8u ps=1.8u
M5 A S M vdd pfet w=0.8u l=0.2u ad=0.4p as=0.4p pd=2.6u ps=2.6u
M6 M S B gnd nfet w=0.4u l=0.2u ad=0.2p as=0.2p pd=1.8u ps=1.8u
M7 M Sn B vdd pfet w=0.8u l=0.2u ad=0.4p as=0.4p pd=2.6u ps=2.6u
.ends pl_mux2i
.subckt pl_fa A B C S CO vdd gnd
M0 A Bn P gnd nfet w=0.4u l=0.2u ad=0.2p as=0.2p pd=1.8u ps=1.8u
M1 A B P vdd pfet w=0.4u l=0.2u ad=0.2p as=0.2p pd=1.8u ps=1.8u
M2 P B An gnd nfet w=0.4u l=0.2u ad=0.2p as=0.2p pd=1.8u ps=1.8u
M3 P Bn An vdd pfet w=0.4u l=0.2u ad=0.2p as=0.2p pd=1.8u ps=1.8u
M4 Bn B gnd gnd nfet w=0.4u l=0.2u ad=0.2p as=0.2p pd=1.8u ps=1.8u
M5 Bn B vdd vdd pfet w=0.4u l=0.2u ad=0.2p as=0.2p pd=1.8u ps=1.8u
M6 gnd A An gnd nfet w=0.4u l=0.2u ad=0.2p as=0.2p pd=1.8u ps=1.8u
M7 vdd A An vdd pfet w=0.4u l=0.2u ad=0.2p as=0.2p pd=1.8u ps=1.8u
M8 An Pn COx gnd nfet w=0.4u l=0.2u ad=0.2p as=0.2p pd=1.8u ps=1.8u
M9 An P COx vdd pfet w=0.4u l=0.2u ad=0.2p as=0.2p pd=1.8u ps=1.8u
M10 COx P Cn gnd nfet w=0.4u l=0.2u ad=0.2p as=0.2p pd=1.8u ps=1.8u
M11 COx Pn Cn vdd pfet w=0.4u l=0.2u ad=0.2p as=0.2p pd=1.8u ps=1.8u
M12 Cn Pn Sx gnd nfet w=0.4u l=0.2u ad=0.2p as=0.2p pd=1.8u ps=1.8u
M13 Cn P Sx vdd pfet w=0.4u l=0.2u ad=0.2p as=0.2p pd=1.8u ps=1.8u
M14 Sx P C gnd nfet w=0.4u l=0.2u ad=0.2p as=0.2p pd=1.8u ps=1.8u
M15 Sx Pn C vdd pfet w=0.4u l=0.2u ad=0.2p as=0.2p pd=1.8u ps=1.8u
M16 Cn C gnd gnd nfet w=0.4u l=0.2u ad=0.2p as=0.2p pd=1.8u ps=1.8u
M17 Cn C vdd vdd pfet w=0.4u l=0.2u ad=0.2p as=0.2p pd=1.8u ps=1.8u
M18 gnd P Pn gnd nfet w=0.4u l=0.2u ad=0.2p as=0.2p pd=1.8u ps=1.8u
M19 vdd P Pn vdd pfet w=0.4u l=0.2u ad=0.2p as=0.2p pd=1.8u ps=1.8u
M20 S Sx gnd gnd nfet w=0.4u l=0.2u ad=0.2p as=0.2p pd=1.8u ps=1.8u
M21 S Sx vdd vdd pfet w=0.8u l=0.2u ad=0.4p as=0.4p pd=2.6u ps=2.6u
M22 gnd COx CO gnd nfet w=0.4u l=0.2u ad=0.2p as=0.2p pd=1.8u ps=1.8u
M23 vdd COx CO vdd pfet w=0.8u l=0.2u ad=0.4p as=0.4p pd=2.6u ps=2.6u
.ends pl_fa
.subckt pl_fb4 A B C0 C1 C2 C3 P vdd gnd
M0 C1 B u0 gnd nfet w=0.4u l=0.2u ad=0.2p as=0.2p pd=1.8u ps=1.8u
M1 C1 Bn u0 vdd pfet w=0.5u l=0.2u ad=0.25p as=0.25p pd=2u ps=2u
M2 u0 Bn C0 gnd nfet w=0.4u l=0.2u ad=0.2p as=0.2p pd=1.8u ps=1.8u
M3 u0 B C0 vdd pfet w=0.5u l=0.2u ad=0.25p as=0.25p pd=2u ps=2u
M4 C2 Bn u1 gnd nfet w=0.4u l=0.2u ad=0.2p as=0.2p pd=1.8u ps=1.8u
M5 C2 B u1 vdd pfet w=0.5u l=0.2u ad=0.25p as=0.25p pd=2u ps=2u
M6 u1 B C3 gnd nfet w=0.4u l=0.2u ad=0.2p as=0.2p pd=1.8u ps=1.8u
M7 u1 Bn C3 vdd pfet w=0.5u l=0.2u ad=0.25p as=0.25p pd=2u ps=2u
M8 u0 An x gnd nfet w=0.4u l=0.2u ad=0.2p as=0.2p pd=1.8u ps=1.8u
M9 u0 A x vdd pfet w=0.5u l=0.2u ad=0.25p as=0.25p pd=2u ps=2u
M10 x A u1 gnd nfet w=0.4u l=0.2u ad=0.2p as=0.2p pd=1.8u ps=1.8u
M11 x An u1 vdd pfet w=0.5u l=0.2u ad=0.25p as=0.25p pd=2u ps=2u
M12 An A gnd gnd nfet w=0.4u l=0.2u ad=0.2p as=0.2p pd=1.8u ps=1.8u
M13 An A vdd vdd pfet w=0.5u l=0.2u ad=0.25p as=0.25p pd=2u ps=2u
M14 gnd B Bn gnd nfet w=0.4u l=0.2u ad=0.2p as=0.2p pd=1.8u ps=1.8u
M15 vdd B Bn vdd pfet w=0.5u l=0.2u ad=0.25p as=0.25p pd=2u ps=2u
M16 Pn x gnd gnd nfet w=0.4u l=0.2u ad=0.2p as=0.2p pd=1.8u ps=1.8u
M17 Pn x vdd vdd pfet w=0.5u l=0.2u ad=0.25p as=0.25p pd=2u ps=2u
M18 gnd Pn P gnd nfet w=0.4u l=0.2u ad=0.2p as=0.2p pd=1.8u ps=1.8u
M19 vdd Pn P vdd pfet w=1u l=0.2u ad=0.5p as=0.5p pd=3u ps=3u
.ends pl_fb4
.subckt pl_cs P A CI K CO Y vdd gnd
M0 A Pn cx gnd nfet w=0.4u l=0.2u ad=0.2p as=0.2p pd=1.8u ps=1.8u
M1 A P cx vdd pfet w=0.6u l=0.2u ad=0.3p as=0.3p pd=2.2u ps=2.2u
M2 cx P CI gnd nfet w=0.4u l=0.2u ad=0.2p as=0.2p pd=1.8u ps=1.8u
M3 cx Pn CI vdd pfet w=0.6u l=0.2u ad=0.3p as=0.3p pd=2.2u ps=2.2u
M4 CI P xn gnd nfet w=0.4u l=0.2u ad=0.2p as=0.2p pd=1.8u ps=1.8u
M5 CI Pn xn vdd pfet w=0.6u l=0.2u ad=0.3p as=0.3p pd=2.2u ps=2.2u
M6 xn Pn CIn gnd nfet w=0.4u l=0.2u ad=0.2p as=0.2p pd=1.8u ps=1.8u
M7 xn P CIn vdd pfet w=0.6u l=0.2u ad=0.3p as=0.3p pd=2.2u ps=2.2u
M8 CIn CI gnd gnd nfet w=0.4u l=0.2u ad=0.2p as=0.2p pd=1.8u ps=1.8u
M9 CIn CI vdd vdd pfet w=0.6u l=0.2u ad=0.3p as=0.3p pd=2.2u ps=2.2u
M10 gnd P Pn gnd nfet w=0.4u l=0.2u ad=0.2p as=0.2p pd=1.8u ps=1.8u
M11 vdd P Pn vdd pfet w=0.6u l=0.2u ad=0.3p as=0.3p pd=2.2u ps=2.2u
M12 Pn K yn gnd nfet w=0.4u l=0.2u ad=0.2p as=0.2p pd=1.8u ps=1.8u
M13 Pn Kn yn vdd pfet w=0.6u l=0.2u ad=0.3p as=0.3p pd=2.2u ps=2.2u
M14 yn Kn xn gnd nfet w=0.4u l=0.2u ad=0.2p as=0.2p pd=1.8u ps=1.8u
M15 yn K xn vdd pfet w=0.6u l=0.2u ad=0.3p as=0.3p pd=2.2u ps=2.2u
M16 Kn K gnd gnd nfet w=0.4u l=0.2u ad=0.2p as=0.2p pd=1.8u ps=1.8u
M17 Kn K vdd vdd pfet w=0.6u l=0.2u ad=0.3p as=0.3p pd=2.2u ps=2.2u
M18 gnd cx COn gnd nfet w=0.4u l=0.2u ad=0.2p as=0.2p pd=1.8u ps=1.8u
M19 vdd cx COn vdd pfet w=0.6u l=0.2u ad=0.3p as=0.3p pd=2.2u ps=2.2u
M20 CO COn gnd gnd nfet w=0.8u l=0.2u ad=0.4p as=0.4p pd=2.6u ps=2.6u
M21 CO COn vdd vdd pfet w=1.2u l=0.2u ad=0.6p as=0.6p pd=3.4u ps=3.4u
M22 gnd yn Y gnd nfet w=0.8u l=0.2u ad=0.4p as=0.4p pd=2.6u ps=2.6u
M23 vdd yn Y vdd pfet w=1.2u l=0.2u ad=0.6p as=0.6p pd=3.4u ps=3.4u
.ends pl_cs
.subckt pl_fill vdd gnd
.ends pl_fill
